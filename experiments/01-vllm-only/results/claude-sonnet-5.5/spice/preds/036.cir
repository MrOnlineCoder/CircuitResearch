* CI2N circuit from experiments/01-vllm-only/results/claude-sonnet-5.5/preds/036.json
* generated by ci2n_to_spice.py
* ---- placeholder values: CI2N netlists carry topology only; edit as needed ----
.param VDD=1.8 VSS=0
.param Rval=10k Cval=1p Ival=10u Vval=0.9
.param Wn=1u Ln=180n Wp=2u Lp=180n Aol=1e5
.model NMOS_CI2N NMOS (level=1 VTO=0.45 KP=200u LAMBDA=0.05)
.model PMOS_CI2N PMOS (level=1 VTO=-0.45 KP=80u LAMBDA=0.05)
.model NPN_CI2N NPN (Is=1e-16 Bf=100 Vaf=50)
.model PNP_CI2N PNP (Is=1e-16 Bf=50 Vaf=50)
.model D_CI2N D (Is=1e-14)

M1 net1 VB1 VDD VDD PMOS_CI2N L={Lp} W={Wp}
M2 net2 VB1 VDD VDD PMOS_CI2N L={Lp} W={Wp}
M3 net3 VB1 VDD VDD PMOS_CI2N L={Lp} W={Wp}
M4 net1 net1 VSS VSS NMOS_CI2N L={Ln} W={Wn}
M5 net4 net1 VSS VSS NMOS_CI2N L={Ln} W={Wn}
M6 net2 VIP VSS VSS NMOS_CI2N L={Ln} W={Wn}
M7 net3 VIN VSS VSS NMOS_CI2N L={Ln} W={Wn}
M8 net5 net2 net4 net4 NMOS_CI2N L={Ln} W={Wn}
M9 VO net3 net4 net4 NMOS_CI2N L={Ln} W={Wn}
M10 net5 net5 VDD VDD PMOS_CI2N L={Lp} W={Wp}
M11 VO net5 VDD VDD PMOS_CI2N L={Lp} W={Wp}
* supply rails (added; not part of the CI2N netlist)
Vsup_VDD VDD 0 {VDD}
Vsup_VSS VSS 0 {VSS}
.op
.end
