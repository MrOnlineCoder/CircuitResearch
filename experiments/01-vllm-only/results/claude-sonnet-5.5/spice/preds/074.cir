* CI2N circuit from experiments/01-vllm-only/results/claude-sonnet-5.5/preds/074.json
* generated by ci2n_to_spice.py
* renamed nets: Vout+ -> Vout_p, Vout- -> Vout_n, Vin+ -> Vin_p, Vin- -> Vin_n
* ---- placeholder values: CI2N netlists carry topology only; edit as needed ----
.param VDD=1.8 VSS=0
.param Rval=10k Cval=1p Ival=10u Vval=0.9
.param Wn=1u Ln=180n Wp=2u Lp=180n Aol=1e5
.model NMOS_CI2N NMOS (level=1 VTO=0.45 KP=200u LAMBDA=0.05)
.model PMOS_CI2N PMOS (level=1 VTO=-0.45 KP=80u LAMBDA=0.05)
.model NPN_CI2N NPN (Is=1e-16 Bf=100 Vaf=50)
.model PNP_CI2N PNP (Is=1e-16 Bf=50 Vaf=50)
.model D_CI2N D (Is=1e-14)

M1 Vout_p VP1 VDD VDD PMOS_CI2N L={Lp} W={Wp}
M2 net1 VP1 VDD VDD PMOS_CI2N L={Lp} W={Wp}
M3 Vout_n VP1 VDD VDD PMOS_CI2N L={Lp} W={Wp}
M4 net2 Vin_p net1 net1 PMOS_CI2N L={Lp} W={Wp}
M5 net3 Vin_n net1 net1 PMOS_CI2N L={Lp} W={Wp}
M6 net4 VP2 net2 net2 PMOS_CI2N L={Lp} W={Wp}
M7 net5 VP2 net3 net3 PMOS_CI2N L={Lp} W={Wp}
M8 net4 VN1 net6 net6 NMOS_CI2N L={Ln} W={Wn}
M9 net5 VN1 net7 net7 NMOS_CI2N L={Ln} W={Wn}
M10 net6 VCMFB VSS VSS NMOS_CI2N L={Ln} W={Wn}
M11 net7 VCMFB VSS VSS NMOS_CI2N L={Ln} W={Wn}
M12 Vout_p net4 VSS VSS NMOS_CI2N L={Ln} W={Wn}
M13 Vout_n net5 VSS VSS NMOS_CI2N L={Ln} W={Wn}
C1 Vout_p net8 {Cval}
R1 net8 net4 {Rval}
C2 Vout_n net9 {Cval}
R2 net9 net5 {Rval}
* supply rails (added; not part of the CI2N netlist)
Vsup_VDD VDD 0 {VDD}
Vsup_VSS VSS 0 {VSS}
.op
.end
