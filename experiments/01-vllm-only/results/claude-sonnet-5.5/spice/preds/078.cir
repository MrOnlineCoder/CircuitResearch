* CI2N circuit from experiments/01-vllm-only/results/claude-sonnet-5.5/preds/078.json
* generated by ci2n_to_spice.py
* ---- placeholder values: CI2N netlists carry topology only; edit as needed ----
.param VDD=1.8 VSS=0
.param Rval=10k Cval=1p Ival=10u Vval=0.9
.param Wn=1u Ln=180n Wp=2u Lp=180n Aol=1e5
.model NMOS_CI2N NMOS (level=1 VTO=0.45 KP=200u LAMBDA=0.05)
.model PMOS_CI2N PMOS (level=1 VTO=-0.45 KP=80u LAMBDA=0.05)
.model NPN_CI2N NPN (Is=1e-16 Bf=100 Vaf=50)
.model PNP_CI2N PNP (Is=1e-16 Bf=50 Vaf=50)
.model D_CI2N D (Is=1e-14)

I1 VDD net1 {Ival}
M1 VA VA VDD VDD PMOS_CI2N L={Lp} W={Wp}
M2 net2 net2 VA VA PMOS_CI2N L={Lp} W={Wp}
M3 net1 net1 VSS VSS NMOS_CI2N L={Ln} W={Wn}
M4 net2 net1 VSS VSS NMOS_CI2N L={Ln} W={Wn}
M5 net3 net1 VSS VSS NMOS_CI2N L={Ln} W={Wn}
M6 Vout net1 VSS VSS NMOS_CI2N L={Ln} W={Wn}
M7 VF VF VDD VDD PMOS_CI2N L={Lp} W={Wp}
M8 VB VF VDD VDD PMOS_CI2N L={Lp} W={Wp}
M9 VF VN net4 net4 NMOS_CI2N L={Ln} W={Wn}
M10 VB VP net4 net4 NMOS_CI2N L={Ln} W={Wn}
M11 net4 net1 VSS VSS NMOS_CI2N L={Ln} W={Wn}
M12 Vout VB VDD VDD PMOS_CI2N L={Lp} W={Wp}
M13 VB net2 Cc_n Cc_n NMOS_CI2N L={Ln} W={Wn}
C1 VB Vout {Cval}
C2 Vout 0 {Cval}
* supply rails (added; not part of the CI2N netlist)
Vsup_VDD VDD 0 {VDD}
Vsup_VSS VSS 0 {VSS}
.op
.end
