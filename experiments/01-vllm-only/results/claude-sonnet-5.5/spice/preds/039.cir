* CI2N circuit from experiments/01-vllm-only/results/claude-sonnet-5.5/preds/039.json
* generated by ci2n_to_spice.py
* ---- placeholder values: CI2N netlists carry topology only; edit as needed ----
.param VDD=1.8 VSS=0
.param Rval=10k Cval=1p Ival=10u Vval=0.9
.param Wn=1u Ln=180n Wp=2u Lp=180n Aol=1e5
.model NMOS_CI2N NMOS (level=1 VTO=0.45 KP=200u LAMBDA=0.05)
.model PMOS_CI2N PMOS (level=1 VTO=-0.45 KP=80u LAMBDA=0.05)
.model NPN_CI2N NPN (Is=1e-16 Bf=100 Vaf=50)
.model PNP_CI2N PNP (Is=1e-16 Bf=50 Vaf=50)
.model D_CI2N D (Is=1e-14)

M1 net_a vg VDD VDD PMOS_CI2N L={Lp} W={Wp}
M2 Vref vg VDD VDD PMOS_CI2N L={Lp} W={Wp}
R1 net_a n1 {Rval}
R2 Vref net_b {Rval}
R3 net_b n2 {Rval}
R4 n1 net_c {Rval}
Q1 0 0 net_c NPN_CI2N
Q2 0 0 n2 NPN_CI2N
M3 s1 vg VDD VDD PMOS_CI2N L={Lp} W={Wp}
M4 s1 VDD 0 0 NMOS_CI2N L={Ln} W={Wn}
M5 n2 s1 VDD VDD PMOS_CI2N L={Lp} W={Wp}
M6 eout s1 VDD VDD PMOS_CI2N L={Lp} W={Wp}
M7 eout vg VDD VDD PMOS_CI2N L={Lp} W={Wp}
M8 eout g89 0 0 NMOS_CI2N L={Ln} W={Wn}
M9 vg g89 0 0 NMOS_CI2N L={Ln} W={Wn}
M10 vg vg VDD VDD PMOS_CI2N L={Lp} W={Wp}
C1 eout n1 {Cval}
M11 tail vg VDD VDD PMOS_CI2N L={Lp} W={Wp}
M12 d12 n1 tail tail NMOS_CI2N L={Ln} W={Wn}
M13 d13 n2 tail tail NMOS_CI2N L={Ln} W={Wn}
M14 d12 d12 0 0 NMOS_CI2N L={Ln} W={Wn}
M15 d13 d13 0 0 NMOS_CI2N L={Ln} W={Wn}
M16 eout d12 0 0 NMOS_CI2N L={Ln} W={Wn}
M17 d19 d13 0 0 NMOS_CI2N L={Ln} W={Wn}
M18 eout d19 VDD VDD PMOS_CI2N L={Lp} W={Wp}
M19 d19 d19 VDD VDD PMOS_CI2N L={Lp} W={Wp}
* supply rails (added; not part of the CI2N netlist)
Vsup_VDD VDD 0 {VDD}
.op
.end
