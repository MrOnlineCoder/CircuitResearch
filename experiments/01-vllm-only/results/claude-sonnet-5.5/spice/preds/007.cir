* CI2N circuit from experiments/01-vllm-only/results/claude-sonnet-5.5/preds/007.json
* generated by ci2n_to_spice.py
* ---- placeholder values: CI2N netlists carry topology only; edit as needed ----
.param VDD=1.8 VSS=0
.param Rval=10k Cval=1p Ival=10u Vval=0.9
.param Wn=1u Ln=180n Wp=2u Lp=180n Aol=1e5
.model NMOS_CI2N NMOS (level=1 VTO=0.45 KP=200u LAMBDA=0.05)
.model PMOS_CI2N PMOS (level=1 VTO=-0.45 KP=80u LAMBDA=0.05)
.model NPN_CI2N NPN (Is=1e-16 Bf=100 Vaf=50)
.model PNP_CI2N PNP (Is=1e-16 Bf=50 Vaf=50)
.model D_CI2N D (Is=1e-14)

M1 net_p1 net_pb VDD VDD PMOS_CI2N L={Lp} W={Wp}
M2 net_nb net_nb VDD VDD PMOS_CI2N L={Lp} W={Wp}
M3 net_pb net_nb net_p1 net_p1 PMOS_CI2N L={Lp} W={Wp}
M4 net_nb OPO 0 0 NMOS_CI2N L={Ln} W={Wn}
M5 net_pb OPO 0 0 NMOS_CI2N L={Ln} W={Wn}
V1 OPO 0 {Vval}
M6 net_c1 net_pb VDD VDD PMOS_CI2N L={Lp} W={Wp}
M7 net_a net_nb net_c1 net_c1 PMOS_CI2N L={Lp} W={Wp}
M8 net_c2 net_pb VDD VDD PMOS_CI2N L={Lp} W={Wp}
M9 net_tail net_nb net_c2 net_c2 PMOS_CI2N L={Lp} W={Wp}
M10 net_c3 net_pb VDD VDD PMOS_CI2N L={Lp} W={Wp}
M11 net_b net_nb net_c3 net_c3 PMOS_CI2N L={Lp} W={Wp}
M12 net_c4 net_pb VDD VDD PMOS_CI2N L={Lp} W={Wp}
M13 VREF net_nb net_c4 net_c4 PMOS_CI2N L={Lp} W={Wp}
M14 net_m1d net_a net_tail net_tail PMOS_CI2N L={Lp} W={Wp}
M15 OPO net_b net_tail net_tail PMOS_CI2N L={Lp} W={Wp}
M16 net_m1d net_m1d 0 0 NMOS_CI2N L={Ln} W={Wn}
M17 OPO net_m1d 0 0 NMOS_CI2N L={Ln} W={Wn}
Q1 0 0 net_a PNP_CI2N
Q2 0 0 net_q2e PNP_CI2N
R1 net_a 0 {Rval}
R2 net_b 0 {Rval}
R3 net_b net_q2e {Rval}
R4 VREF 0 {Rval}
* supply rails (added; not part of the CI2N netlist)
Vsup_VDD VDD 0 {VDD}
.op
.end
