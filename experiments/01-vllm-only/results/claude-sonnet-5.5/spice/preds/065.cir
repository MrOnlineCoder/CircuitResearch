* CI2N circuit from experiments/01-vllm-only/results/claude-sonnet-5.5/preds/065.json
* generated by ci2n_to_spice.py
* ---- placeholder values: CI2N netlists carry topology only; edit as needed ----
.param VDD=1.8 VSS=0
.param Rval=10k Cval=1p Ival=10u Vval=0.9
.param Wn=1u Ln=180n Wp=2u Lp=180n Aol=1e5
.model NMOS_CI2N NMOS (level=1 VTO=0.45 KP=200u LAMBDA=0.05)
.model PMOS_CI2N PMOS (level=1 VTO=-0.45 KP=80u LAMBDA=0.05)
.model NPN_CI2N NPN (Is=1e-16 Bf=100 Vaf=50)
.model PNP_CI2N PNP (Is=1e-16 Bf=50 Vaf=50)
.model D_CI2N D (Is=1e-14)

M1 net_t VB1 VDD VDD PMOS_CI2N L={Lp} W={Wp}
M2 net_d VIN net_t net_t NMOS_CI2N L={Ln} W={Wn}
M3 net_b FB net_t net_t NMOS_CI2N L={Ln} W={Wn}
M4 net_f net_e VDD VDD PMOS_CI2N L={Lp} W={Wp}
M5 net_e net_e VDD VDD PMOS_CI2N L={Lp} W={Wp}
M6 net_a net_a net_f net_f PMOS_CI2N L={Lp} W={Wp}
M7 net_c net_a net_e net_e PMOS_CI2N L={Lp} W={Wp}
M8 net_a VB2 net_b net_b NMOS_CI2N L={Ln} W={Wn}
M9 net_c VB2 net_d net_d NMOS_CI2N L={Ln} W={Wn}
M10 net_b VB3 0 0 NMOS_CI2N L={Ln} W={Wn}
M11 net_d VB3 0 0 NMOS_CI2N L={Ln} W={Wn}
M12 net_m VB1 VDD VDD PMOS_CI2N L={Lp} W={Wp}
M13 net_m net_o VDD VDD PMOS_CI2N L={Lp} W={Wp}
M14 net_o VB1 VDD VDD PMOS_CI2N L={Lp} W={Wp}
M15 net_o net_o VDD VDD PMOS_CI2N L={Lp} W={Wp}
M16 net_o net_c net_s net_s NMOS_CI2N L={Ln} W={Wn}
M17 net_o net_s 0 0 NMOS_CI2N L={Ln} W={Wn}
M18 net_m net_m 0 0 NMOS_CI2N L={Ln} W={Wn}
M19 net_s net_m 0 0 NMOS_CI2N L={Ln} W={Wn}
M20 VOUT net_o VDD VDD PMOS_CI2N L={Lp} W={Wp}
R1 VOUT FB {Rval}
R2 FB 0 {Rval}
C1 VOUT 0 {Cval}
R3 VOUT 0 {Rval}
C2 net_d VOUT {Cval}
* supply rails (added; not part of the CI2N netlist)
Vsup_VDD VDD 0 {VDD}
.op
.end
