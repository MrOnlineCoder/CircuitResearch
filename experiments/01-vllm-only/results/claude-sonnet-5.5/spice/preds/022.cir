* CI2N circuit from experiments/01-vllm-only/results/claude-sonnet-5.5/preds/022.json
* generated by ci2n_to_spice.py
* ---- placeholder values: CI2N netlists carry topology only; edit as needed ----
.param VDD=1.8 VSS=0
.param Rval=10k Cval=1p Ival=10u Vval=0.9
.param Wn=1u Ln=180n Wp=2u Lp=180n Aol=1e5
.model NMOS_CI2N NMOS (level=1 VTO=0.45 KP=200u LAMBDA=0.05)
.model PMOS_CI2N PMOS (level=1 VTO=-0.45 KP=80u LAMBDA=0.05)
.model NPN_CI2N NPN (Is=1e-16 Bf=100 Vaf=50)
.model PNP_CI2N PNP (Is=1e-16 Bf=50 Vaf=50)
.model D_CI2N D (Is=1e-14)

M1 net1 vi1 net3 net3 NMOS_CI2N L={Ln} W={Wn}
M2 net2 vi2 net3 net3 NMOS_CI2N L={Ln} W={Wn}
M3 net1 VBP_g VDD VDD PMOS_CI2N L={Lp} W={Wp}
M4 net2 VBP_g VDD VDD PMOS_CI2N L={Lp} W={Wp}
M5 vo1 net1 VDD VDD PMOS_CI2N L={Lp} W={Wp}
M6 vo2 net2 VDD VDD PMOS_CI2N L={Lp} W={Wp}
M7 net3 VBN_g VSS VSS NMOS_CI2N L={Ln} W={Wn}
M8 vo1 VBN_g VSS VSS NMOS_CI2N L={Ln} W={Wn}
M9 vo2 VBN_g VSS VSS NMOS_CI2N L={Ln} W={Wn}
R1 net1 net4 {Rval}
C1 net4 vo1 {Cval}
R2 net2 net5 {Rval}
C2 net5 vo2 {Cval}
V1 VDD VBP_g {Vval}
V2 VBN_g VSS {Vval}
.op
.end
