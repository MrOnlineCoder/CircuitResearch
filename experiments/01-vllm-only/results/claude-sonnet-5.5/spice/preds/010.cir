* CI2N circuit from experiments/01-vllm-only/results/claude-sonnet-5.5/preds/010.json
* generated by ci2n_to_spice.py
* renamed nets: Vi- -> Vi_n, Vi+ -> Vi_p
* ---- placeholder values: CI2N netlists carry topology only; edit as needed ----
.param VDD=1.8 VSS=0
.param Rval=10k Cval=1p Ival=10u Vval=0.9
.param Wn=1u Ln=180n Wp=2u Lp=180n Aol=1e5
.model NMOS_CI2N NMOS (level=1 VTO=0.45 KP=200u LAMBDA=0.05)
.model PMOS_CI2N PMOS (level=1 VTO=-0.45 KP=80u LAMBDA=0.05)
.model NPN_CI2N NPN (Is=1e-16 Bf=100 Vaf=50)
.model PNP_CI2N PNP (Is=1e-16 Bf=50 Vaf=50)
.model D_CI2N D (Is=1e-14)

M1 net1 VBP1 VDD VDD PMOS_CI2N L={Lp} W={Wp}
M2 net2 Vi_n net1 net1 PMOS_CI2N L={Lp} W={Wp}
M3 net3 Vi_p net1 net1 PMOS_CI2N L={Lp} W={Wp}
M4 net4 net5 VDD VDD PMOS_CI2N L={Lp} W={Wp}
M5 net6 net5 VDD VDD PMOS_CI2N L={Lp} W={Wp}
M6 net7 VBN2 net4 net4 PMOS_CI2N L={Lp} W={Wp}
M7 net3 VBN2 net6 net6 PMOS_CI2N L={Lp} W={Wp}
M8 net7 VBN1 net8 net8 NMOS_CI2N L={Ln} W={Wn}
M9 net3 VBN1 net9 net9 NMOS_CI2N L={Ln} W={Wn}
M10 net2 net10 0 0 NMOS_CI2N L={Ln} W={Wn}
M11 net3 net10 0 0 NMOS_CI2N L={Ln} W={Wn}
M12 net11 net10 0 0 NMOS_CI2N L={Ln} W={Wn}
M13 net12 VBP1 VDD VDD PMOS_CI2N L={Lp} W={Wp}
M14 net13 VBP2 net12 net12 PMOS_CI2N L={Lp} W={Wp}
M15 net14 net7 net15 net15 PMOS_CI2N L={Lp} W={Wp}
M16 net14 net16 0 0 NMOS_CI2N L={Ln} W={Wn}
M17 net13 net16 0 0 NMOS_CI2N L={Ln} W={Wn}
M18 Vo net7 VDD VDD PMOS_CI2N L={Lp} W={Wp}
M19 Vo net13 0 0 NMOS_CI2N L={Ln} W={Wn}
C1 net3 Vo {Cval}
R1 net13 net17 {Rval}
C2 net17 0 {Cval}
C3 Vo 0 {Cval}
* supply rails (added; not part of the CI2N netlist)
Vsup_VDD VDD 0 {VDD}
.op
.end
