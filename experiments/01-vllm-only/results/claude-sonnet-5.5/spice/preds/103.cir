* CI2N circuit from experiments/01-vllm-only/results/claude-sonnet-5.5/preds/103.json
* generated by ci2n_to_spice.py
* renamed nets: VIN+ -> VIN_p, VIN- -> VIN_n
* ---- placeholder values: CI2N netlists carry topology only; edit as needed ----
.param VDD=1.8 VSS=0
.param Rval=10k Cval=1p Ival=10u Vval=0.9
.param Wn=1u Ln=180n Wp=2u Lp=180n Aol=1e5
.model NMOS_CI2N NMOS (level=1 VTO=0.45 KP=200u LAMBDA=0.05)
.model PMOS_CI2N PMOS (level=1 VTO=-0.45 KP=80u LAMBDA=0.05)
.model NPN_CI2N NPN (Is=1e-16 Bf=100 Vaf=50)
.model PNP_CI2N PNP (Is=1e-16 Bf=50 Vaf=50)
.model D_CI2N D (Is=1e-14)

M1 tail Vb1 net_x net_x PMOS_CI2N L={Lp} W={Wp}
M2 netC VIN_p tail tail PMOS_CI2N L={Lp} W={Wp}
M3 netB VIN_p tail tail PMOS_CI2N L={Lp} W={Wp}
M4 netA VIN_n tail tail PMOS_CI2N L={Lp} W={Wp}
M5 netD VIN_n tail tail PMOS_CI2N L={Lp} W={Wp}
M6 netA Vb2 n6 n6 NMOS_CI2N L={Ln} W={Wn}
M7 netA Vb2 n7 n7 NMOS_CI2N L={Ln} W={Wn}
M8 netB Vb2 n8 n8 NMOS_CI2N L={Ln} W={Wn}
M9 netB Vb2 n9 n9 NMOS_CI2N L={Ln} W={Wn}
M10 netC netA 0 0 NMOS_CI2N L={Ln} W={Wn}
M11 n6 netA 0 0 NMOS_CI2N L={Ln} W={Wn}
M12 n7 Vb3 0 0 NMOS_CI2N L={Ln} W={Wn}
M13 n8 Vb3 0 0 NMOS_CI2N L={Ln} W={Wn}
M14 n9 netB 0 0 NMOS_CI2N L={Ln} W={Wn}
M15 netD netB 0 0 NMOS_CI2N L={Ln} W={Wn}
M16 net_x net_y VDD VDD PMOS_CI2N L={Lp} W={Wp}
M17 net_z net_y VDD VDD PMOS_CI2N L={Lp} W={Wp}
M18 net_y Vb6 net_x net_x PMOS_CI2N L={Lp} W={Wp}
M19 VOUT Vb6 net_z net_z PMOS_CI2N L={Lp} W={Wp}
M20 net_y Vb5 n20 n20 NMOS_CI2N L={Ln} W={Wn}
M21 VOUT Vb5 n21 n21 NMOS_CI2N L={Ln} W={Wn}
M22 n20 Vb4 netC netC NMOS_CI2N L={Ln} W={Wn}
M23 n21 Vb4 netD netD NMOS_CI2N L={Ln} W={Wn}
* supply rails (added; not part of the CI2N netlist)
Vsup_VDD VDD 0 {VDD}
.op
.end
