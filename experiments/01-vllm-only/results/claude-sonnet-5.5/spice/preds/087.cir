* CI2N circuit from experiments/01-vllm-only/results/claude-sonnet-5.5/preds/087.json
* generated by ci2n_to_spice.py
* renamed nets: Vin- -> Vin_n, Vin+ -> Vin_p
* ---- placeholder values: CI2N netlists carry topology only; edit as needed ----
.param VDD=1.8 VSS=0
.param Rval=10k Cval=1p Ival=10u Vval=0.9
.param Wn=1u Ln=180n Wp=2u Lp=180n Aol=1e5
.model NMOS_CI2N NMOS (level=1 VTO=0.45 KP=200u LAMBDA=0.05)
.model PMOS_CI2N PMOS (level=1 VTO=-0.45 KP=80u LAMBDA=0.05)
.model NPN_CI2N NPN (Is=1e-16 Bf=100 Vaf=50)
.model PNP_CI2N PNP (Is=1e-16 Bf=50 Vaf=50)
.model D_CI2N D (Is=1e-14)

M1 BNcas VB VDD VDD PMOS_CI2N L={Lp} W={Wp}
R1 BNcas BN {Rval}
M2 BN BNcas nb1 nb1 NMOS_CI2N L={Ln} W={Wn}
M3 nb1 BN 0 0 NMOS_CI2N L={Ln} W={Wn}
M4 nb6 BP VDD VDD PMOS_CI2N L={Lp} W={Wp}
M5 BP BPcas nb6 nb6 PMOS_CI2N L={Lp} W={Wp}
R2 BP BPcas {Rval}
M6 BPcas BNcas nb5 nb5 NMOS_CI2N L={Ln} W={Wn}
M7 nb5 BN 0 0 NMOS_CI2N L={Ln} W={Wn}
M8 netR Vin_n tail tail NMOS_CI2N L={Ln} W={Wn}
M9 netL Vin_p tail tail NMOS_CI2N L={Ln} W={Wn}
M10 tail BNcas na13 na13 NMOS_CI2N L={Ln} W={Wn}
M11 na13 BN 0 0 NMOS_CI2N L={Ln} W={Wn}
M12 netL BP VDD VDD PMOS_CI2N L={Lp} W={Wp}
M13 netR BP VDD VDD PMOS_CI2N L={Lp} W={Wp}
M14 netA BPcas netL netL PMOS_CI2N L={Lp} W={Wp}
M15 netB BPcas netR netR PMOS_CI2N L={Lp} W={Wp}
M16 netA BNcas na15 na15 NMOS_CI2N L={Ln} W={Wn}
M17 na15 netA 0 0 NMOS_CI2N L={Ln} W={Wn}
M18 netB BNcas na17 na17 NMOS_CI2N L={Ln} W={Wn}
M19 na17 netB 0 0 NMOS_CI2N L={Ln} W={Wn}
M20 netD BNcas na19 na19 NMOS_CI2N L={Ln} W={Wn}
M21 na19 netB 0 0 NMOS_CI2N L={Ln} W={Wn}
M22 netE netD VDD VDD PMOS_CI2N L={Lp} W={Wp}
M23 netD BPcas netE netE PMOS_CI2N L={Lp} W={Wp}
M24 netF netD VDD VDD PMOS_CI2N L={Lp} W={Wp}
M25 Vout BPcas netF netF PMOS_CI2N L={Lp} W={Wp}
M26 Vout BNcas na21 na21 NMOS_CI2N L={Ln} W={Wn}
M27 na21 netA 0 0 NMOS_CI2N L={Ln} W={Wn}
* supply rails (added; not part of the CI2N netlist)
Vsup_VDD VDD 0 {VDD}
.op
.end
