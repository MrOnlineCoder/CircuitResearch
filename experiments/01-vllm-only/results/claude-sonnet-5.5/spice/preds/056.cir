* CI2N circuit from experiments/01-vllm-only/results/claude-sonnet-5.5/preds/056.json
* generated by ci2n_to_spice.py
* ---- placeholder values: CI2N netlists carry topology only; edit as needed ----
.param VDD=1.8 VSS=0
.param Rval=10k Cval=1p Ival=10u Vval=0.9
.param Wn=1u Ln=180n Wp=2u Lp=180n Aol=1e5
.model NMOS_CI2N NMOS (level=1 VTO=0.45 KP=200u LAMBDA=0.05)
.model PMOS_CI2N PMOS (level=1 VTO=-0.45 KP=80u LAMBDA=0.05)
.model NPN_CI2N NPN (Is=1e-16 Bf=100 Vaf=50)
.model PNP_CI2N PNP (Is=1e-16 Bf=50 Vaf=50)
.model D_CI2N D (Is=1e-14)

M1 net_a vi1 net_tail net_tail NMOS_CI2N L={Ln} W={Wn}
M2 net_b vi2 net_tail net_tail NMOS_CI2N L={Ln} W={Wn}
M3 net_tail VBN VSS VSS NMOS_CI2N L={Ln} W={Wn}
M4 vo1 VBN VSS VSS NMOS_CI2N L={Ln} W={Wn}
M5 vo2 VBN VSS VSS NMOS_CI2N L={Ln} W={Wn}
M6 net_a VBP VDD VDD PMOS_CI2N L={Lp} W={Wp}
M7 net_b VBP VDD VDD PMOS_CI2N L={Lp} W={Wp}
M8 vo1 net_a net_s7 net_s7 PMOS_CI2N L={Lp} W={Wp}
M9 vo2 net_b net_s6 net_s6 PMOS_CI2N L={Lp} W={Wp}
M10 net_s7 vo1 VDD VDD PMOS_CI2N L={Lp} W={Wp}
M11 net_s6 vo2 VDD VDD PMOS_CI2N L={Lp} W={Wp}
R1 net_a net_c1 {Rval}
C1 net_c1 vo1 {Cval}
R2 net_b net_c2 {Rval}
C2 net_c2 vo2 {Cval}
V1 VDD VBP {Vval}
V2 VBN VSS {Vval}
.op
.end
