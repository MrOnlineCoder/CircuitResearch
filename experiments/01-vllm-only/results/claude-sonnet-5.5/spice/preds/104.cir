* CI2N circuit from experiments/01-vllm-only/results/claude-sonnet-5.5/preds/104.json
* generated by ci2n_to_spice.py
* renamed nets: Vin+ -> Vin_p, Vin- -> Vin_n, Vout- -> Vout_n, Vout+ -> Vout_p
* ---- placeholder values: CI2N netlists carry topology only; edit as needed ----
.param VDD=1.8 VSS=0
.param Rval=10k Cval=1p Ival=10u Vval=0.9
.param Wn=1u Ln=180n Wp=2u Lp=180n Aol=1e5
.model NMOS_CI2N NMOS (level=1 VTO=0.45 KP=200u LAMBDA=0.05)
.model PMOS_CI2N PMOS (level=1 VTO=-0.45 KP=80u LAMBDA=0.05)
.model NPN_CI2N NPN (Is=1e-16 Bf=100 Vaf=50)
.model PNP_CI2N PNP (Is=1e-16 Bf=50 Vaf=50)
.model D_CI2N D (Is=1e-14)

.subckt DIDO_AMP inp inn outp outn
E1 outp 0 inp inn {Aol/2}
E2 outn 0 inn inp {Aol/2}
.ends DIDO_AMP

M1 net_mid V1 0 0 NMOS_CI2N L={Ln} W={Wn}
M2 tail V2 net_mid net_mid NMOS_CI2N L={Ln} W={Wn}
M3 A Vin_p tail tail NMOS_CI2N L={Ln} W={Wn}
M4 B Vin_n tail tail NMOS_CI2N L={Ln} W={Wn}
M5 A V3 VDD VDD PMOS_CI2N L={Lp} W={Wp}
M6 B V3 VDD VDD PMOS_CI2N L={Lp} W={Wp}
M7 Vout_n C A A PMOS_CI2N L={Lp} W={Wp}
M8 Vout_p D B B PMOS_CI2N L={Lp} W={Wp}
M9 Vout_n V4 net_m10 net_m10 NMOS_CI2N L={Ln} W={Wn}
M10 Vout_p V4 net_m11 net_m11 NMOS_CI2N L={Ln} W={Wn}
M11 net_m10 G E E NMOS_CI2N L={Ln} W={Wn}
M12 net_m11 H F F NMOS_CI2N L={Ln} W={Wn}
M13 E VCMFB 0 0 NMOS_CI2N L={Ln} W={Wn}
M14 F VCMFB 0 0 NMOS_CI2N L={Ln} W={Wn}
X1 B A D C DIDO_AMP
X2 F E H G DIDO_AMP
* supply rails (added; not part of the CI2N netlist)
Vsup_VDD VDD 0 {VDD}
.op
.end
