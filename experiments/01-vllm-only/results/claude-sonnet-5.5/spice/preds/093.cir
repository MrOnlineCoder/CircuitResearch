* CI2N circuit from experiments/01-vllm-only/results/claude-sonnet-5.5/preds/093.json
* generated by ci2n_to_spice.py
* renamed nets: VIN- -> VIN_n, VIN+ -> VIN_p
* ---- placeholder values: CI2N netlists carry topology only; edit as needed ----
.param VDD=1.8 VSS=0
.param Rval=10k Cval=1p Ival=10u Vval=0.9
.param Wn=1u Ln=180n Wp=2u Lp=180n Aol=1e5
.model NMOS_CI2N NMOS (level=1 VTO=0.45 KP=200u LAMBDA=0.05)
.model PMOS_CI2N PMOS (level=1 VTO=-0.45 KP=80u LAMBDA=0.05)
.model NPN_CI2N NPN (Is=1e-16 Bf=100 Vaf=50)
.model PNP_CI2N PNP (Is=1e-16 Bf=50 Vaf=50)
.model D_CI2N D (Is=1e-14)

M1 net1 net1 VCC VCC PMOS_CI2N L={Lp} W={Wp}
R1 net1 net2 {Rval}
M2 net2 net2 0 0 NMOS_CI2N L={Ln} W={Wn}
M3 net3 net1 VCC VCC PMOS_CI2N L={Lp} W={Wp}
M4 VOUT net1 VCC VCC PMOS_CI2N L={Lp} W={Wp}
M5 net4 VIN_n net3 net3 PMOS_CI2N L={Lp} W={Wp}
M6 net5 VIN_p net3 net3 PMOS_CI2N L={Lp} W={Wp}
M7 net4 net4 0 0 NMOS_CI2N L={Ln} W={Wn}
M8 net5 net4 0 0 NMOS_CI2N L={Ln} W={Wn}
M9 VOUT net5 0 0 NMOS_CI2N L={Ln} W={Wn}
C1 VOUT net5 {Cval}
* supply rails (added; not part of the CI2N netlist)
Vsup_VCC VCC 0 {VDD}
.op
.end
