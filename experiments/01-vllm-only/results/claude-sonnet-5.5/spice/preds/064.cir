* CI2N circuit from experiments/01-vllm-only/results/claude-sonnet-5.5/preds/064.json
* generated by ci2n_to_spice.py
* renamed nets: Vin- -> Vin_n, Vin+ -> Vin_p
* ---- placeholder values: CI2N netlists carry topology only; edit as needed ----
.param VDD=1.8 VSS=0
.param Rval=10k Cval=1p Ival=10u Vval=0.9
.param Wn=1u Ln=180n Wp=2u Lp=180n Aol=1e5
.model NMOS_CI2N NMOS (level=1 VTO=0.45 KP=200u LAMBDA=0.05)
.model PMOS_CI2N PMOS (level=1 VTO=-0.45 KP=80u LAMBDA=0.05)
.model NPN_CI2N NPN (Is=1e-16 Bf=100 Vaf=50)
.model PNP_CI2N PNP (Is=1e-16 Bf=50 Vaf=50)
.model D_CI2N D (Is=1e-14)

M1 net1 net1 VDD VDD PMOS_CI2N L={Lp} W={Wp}
M2 net2 net1 VDD VDD PMOS_CI2N L={Lp} W={Wp}
M3 net2 net3 net4 net4 NMOS_CI2N L={Ln} W={Wn}
M4 net3 net4 net5 net5 NMOS_CI2N L={Ln} W={Wn}
R1 net4 VSS {Rval}
M5 net6 net2 VDD VDD PMOS_CI2N L={Lp} W={Wp}
M6 net7 net2 net6 net6 PMOS_CI2N L={Lp} W={Wp}
M7 net8 Vin_n net7 net7 NMOS_CI2N L={Ln} W={Wn}
M8 net9 Vin_p net7 net7 NMOS_CI2N L={Ln} W={Wn}
M9 net10 net10 VDD VDD PMOS_CI2N L={Lp} W={Wp}
M10 net11 net10 VDD VDD PMOS_CI2N L={Lp} W={Wp}
M11 net12 net12 VSS VSS NMOS_CI2N L={Ln} W={Wn}
M12 net8 net8 net12 net12 NMOS_CI2N L={Ln} W={Wn}
M13 net13 net13 VSS VSS NMOS_CI2N L={Ln} W={Wn}
M14 net11 net13 VSS VSS NMOS_CI2N L={Ln} W={Wn}
M15 net14 net10 VDD VDD PMOS_CI2N L={Lp} W={Wp}
M16 net15 net14 net14 net14 PMOS_CI2N L={Lp} W={Wp}
M17 VOUT net2 net15 net15 NMOS_CI2N L={Ln} W={Wn}
M18 VOUT net11 net16 net16 NMOS_CI2N L={Ln} W={Wn}
M19 net16 net13 VSS VSS NMOS_CI2N L={Ln} W={Wn}
R2 net11 net17 {Rval}
C1 net17 VOUT {Cval}
* supply rails (added; not part of the CI2N netlist)
Vsup_VDD VDD 0 {VDD}
Vsup_VSS VSS 0 {VSS}
.op
.end
