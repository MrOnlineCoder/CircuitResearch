* CI2N circuit from experiments/01-vllm-only/results/claude-sonnet-5.5/preds/127.json
* generated by ci2n_to_spice.py
* ---- placeholder values: CI2N netlists carry topology only; edit as needed ----
.param VDD=1.8 VSS=0
.param Rval=10k Cval=1p Ival=10u Vval=0.9
.param Wn=1u Ln=180n Wp=2u Lp=180n Aol=1e5
.model NMOS_CI2N NMOS (level=1 VTO=0.45 KP=200u LAMBDA=0.05)
.model PMOS_CI2N PMOS (level=1 VTO=-0.45 KP=80u LAMBDA=0.05)
.model NPN_CI2N NPN (Is=1e-16 Bf=100 Vaf=50)
.model PNP_CI2N PNP (Is=1e-16 Bf=50 Vaf=50)
.model D_CI2N D (Is=1e-14)

M1 net1 Vin1 0 0 NMOS_CI2N L={Ln} W={Wn}
M2 net1 Vref1 0 0 NMOS_CI2N L={Ln} W={Wn}
M3 net2 Vin2 0 0 NMOS_CI2N L={Ln} W={Wn}
M4 net2 Vref2 0 0 NMOS_CI2N L={Ln} W={Wn}
M5 net3 Vout1 net1 net1 NMOS_CI2N L={Ln} W={Wn}
M6 net4 Vout2 net2 net2 NMOS_CI2N L={Ln} W={Wn}
M7 net5 CLK net3 net3 NMOS_CI2N L={Ln} W={Wn}
M8 net5 CLK net4 net4 NMOS_CI2N L={Ln} W={Wn}
M9 net5 Vout1 VDD VDD PMOS_CI2N L={Lp} W={Wp}
M10 net5 Vout2 VDD VDD PMOS_CI2N L={Lp} W={Wp}
M11 net5 CLK VDD VDD PMOS_CI2N L={Lp} W={Wp}
M12 net5 CLK VDD VDD PMOS_CI2N L={Lp} W={Wp}
V1 Vref1 0 {Vval}
V2 Vref2 0 {Vval}
* supply rails (added; not part of the CI2N netlist)
Vsup_VDD VDD 0 {VDD}
.op
.end
