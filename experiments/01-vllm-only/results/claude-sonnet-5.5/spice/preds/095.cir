* CI2N circuit from experiments/01-vllm-only/results/claude-sonnet-5.5/preds/095.json
* generated by ci2n_to_spice.py
* ---- placeholder values: CI2N netlists carry topology only; edit as needed ----
.param VDD=1.8 VSS=0
.param Rval=10k Cval=1p Ival=10u Vval=0.9
.param Wn=1u Ln=180n Wp=2u Lp=180n Aol=1e5
.model NMOS_CI2N NMOS (level=1 VTO=0.45 KP=200u LAMBDA=0.05)
.model PMOS_CI2N PMOS (level=1 VTO=-0.45 KP=80u LAMBDA=0.05)
.model NPN_CI2N NPN (Is=1e-16 Bf=100 Vaf=50)
.model PNP_CI2N PNP (Is=1e-16 Bf=50 Vaf=50)
.model D_CI2N D (Is=1e-14)

I1 VDD net_bias {Ival}
M1 net_bias net_bias VSS VSS NMOS_CI2N L={Ln} W={Wn}
M2 net_tail net_bias VSS VSS NMOS_CI2N L={Ln} W={Wn}
M3 VOUT net_bias VSS VSS NMOS_CI2N L={Ln} W={Wn}
M4 net_d1 net_ref net_s1 VDD PMOS_CI2N L={Lp} W={Wp}
M5 net_s1 net_ref VDD VDD PMOS_CI2N L={Lp} W={Wp}
M6 net_o1 net_ref net_s2 VDD PMOS_CI2N L={Lp} W={Wp}
M7 net_s2 net_ref VDD VDD PMOS_CI2N L={Lp} W={Wp}
M8 net_d1 VN net_tail net_tail NMOS_CI2N L={Ln} W={Wn}
M9 net_o1 VP net_tail net_tail NMOS_CI2N L={Ln} W={Wn}
M10 VOUT net_o1 VDD VDD PMOS_CI2N L={Lp} W={Wp}
C1 net_o1 VOUT {Cval}
C2 net_ref VREF {Cval}
C3 VOUT 0 {Cval}
* supply rails (added; not part of the CI2N netlist)
Vsup_VDD VDD 0 {VDD}
Vsup_VSS VSS 0 {VSS}
.op
.end
