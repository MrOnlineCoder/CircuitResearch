* CI2N circuit from experiments/01-vllm-only/results/claude-sonnet-5.5/preds/113.json
* generated by ci2n_to_spice.py
* renamed nets: VIN- -> VIN_n, VIN+ -> VIN_p
* ---- placeholder values: CI2N netlists carry topology only; edit as needed ----
.param VDD=1.8 VSS=0
.param Rval=10k Cval=1p Ival=10u Vval=0.9
.param Wn=1u Ln=180n Wp=2u Lp=180n Aol=1e5
.model NMOS_CI2N NMOS (level=1 VTO=0.45 KP=200u LAMBDA=0.05)
.model PMOS_CI2N PMOS (level=1 VTO=-0.45 KP=80u LAMBDA=0.05)
.model NPN_CI2N NPN (Is=1e-16 Bf=100 Vaf=50)
.model PNP_CI2N PNP (Is=1e-16 Bf=50 Vaf=50)
.model D_CI2N D (Is=1e-14)

I1 VDD_bias net_b {Ival}
M1 net_m11 net_m11 VDD VDD PMOS_CI2N L={Lp} W={Wp}
M2 net_b2 net_b2 net_m11 net_m11 PMOS_CI2N L={Lp} W={Wp}
M3 net_b net_b net_b2 net_b2 PMOS_CI2N L={Lp} W={Wp}
M4 net_b net_bias 0 0 NMOS_CI2N L={Ln} W={Wn}
M5 net_bias net_bias 0 0 NMOS_CI2N L={Ln} W={Wn}
M6 net_tail net_bias 0 0 NMOS_CI2N L={Ln} W={Wn}
M7 VOUT net_bias 0 0 NMOS_CI2N L={Ln} W={Wn}
M8 net1 net1 VDD VDD PMOS_CI2N L={Lp} W={Wp}
M9 net2 net1 VDD VDD PMOS_CI2N L={Lp} W={Wp}
M10 net1 VIN_n net_tail net_tail NMOS_CI2N L={Ln} W={Wn}
M11 net2 VIN_p net_tail net_tail NMOS_CI2N L={Ln} W={Wn}
M12 net3 net_bias2 net2 net2 PMOS_CI2N L={Lp} W={Wp}
C1 net3 VOUT {Cval}
M13 VOUT net2 VDD VDD PMOS_CI2N L={Lp} W={Wp}
C2 VOUT 0 {Cval}
* supply rails (added; not part of the CI2N netlist)
Vsup_VDD_bias VDD_bias 0 {VDD}
Vsup_VDD VDD 0 {VDD}
.op
.end
