* CI2N circuit from experiments/01-vllm-only/results/claude-sonnet-5.5/preds/099.json
* generated by ci2n_to_spice.py
* ---- placeholder values: CI2N netlists carry topology only; edit as needed ----
.param VDD=1.8 VSS=0
.param Rval=10k Cval=1p Ival=10u Vval=0.9
.param Wn=1u Ln=180n Wp=2u Lp=180n Aol=1e5
.model NMOS_CI2N NMOS (level=1 VTO=0.45 KP=200u LAMBDA=0.05)
.model PMOS_CI2N PMOS (level=1 VTO=-0.45 KP=80u LAMBDA=0.05)
.model NPN_CI2N NPN (Is=1e-16 Bf=100 Vaf=50)
.model PNP_CI2N PNP (Is=1e-16 Bf=50 Vaf=50)
.model D_CI2N D (Is=1e-14)

M1 P VIN1 net1 net1 NMOS_CI2N L={Ln} W={Wn}
M2 Q VIN2 net1 net1 NMOS_CI2N L={Ln} W={Wn}
M3 X Y P P NMOS_CI2N L={Ln} W={Wn}
M4 Y X Q Q NMOS_CI2N L={Ln} W={Wn}
M5 net1 CK 0 0 NMOS_CI2N L={Ln} W={Wn}
M6 X Y VDD VDD PMOS_CI2N L={Lp} W={Wp}
M7 Y X VDD VDD PMOS_CI2N L={Lp} W={Wp}
M8 P CK VDD VDD PMOS_CI2N L={Lp} W={Wp}
M9 Q CK VDD VDD PMOS_CI2N L={Lp} W={Wp}
M10 X CK VDD VDD PMOS_CI2N L={Lp} W={Wp}
M11 Y CK VDD VDD PMOS_CI2N L={Lp} W={Wp}
* supply rails (added; not part of the CI2N netlist)
Vsup_VDD VDD 0 {VDD}
.op
.end
