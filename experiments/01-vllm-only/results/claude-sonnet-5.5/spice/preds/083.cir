* CI2N circuit from experiments/01-vllm-only/results/claude-sonnet-5.5/preds/083.json
* generated by ci2n_to_spice.py
* renamed nets: Vin- -> Vin_n, Vin+ -> Vin_p
* ---- placeholder values: CI2N netlists carry topology only; edit as needed ----
.param VDD=1.8 VSS=0
.param Rval=10k Cval=1p Ival=10u Vval=0.9
.param Wn=1u Ln=180n Wp=2u Lp=180n Aol=1e5
.model NMOS_CI2N NMOS (level=1 VTO=0.45 KP=200u LAMBDA=0.05)
.model PMOS_CI2N PMOS (level=1 VTO=-0.45 KP=80u LAMBDA=0.05)
.model NPN_CI2N NPN (Is=1e-16 Bf=100 Vaf=50)
.model PNP_CI2N PNP (Is=1e-16 Bf=50 Vaf=50)
.model D_CI2N D (Is=1e-14)

M1 net_p net_p VDD VDD PMOS_CI2N L={Lp} W={Wp}
M2 net_p net_p VDD VDD PMOS_CI2N L={Lp} W={Wp}
M3 tail net_p VDD VDD PMOS_CI2N L={Lp} W={Wp}
M4 n2 Vin_n tail tail PMOS_CI2N L={Lp} W={Wp}
M5 n3 Vin_p tail tail PMOS_CI2N L={Lp} W={Wp}
R1 net_p net_b {Rval}
M6 net_b net_b 0 0 NMOS_CI2N L={Ln} W={Wn}
M7 net_c net_b 0 0 NMOS_CI2N L={Ln} W={Wn}
M8 net_p net_p net_c net_c NMOS_CI2N L={Ln} W={Wn}
M9 net_d net_d VDD VDD PMOS_CI2N L={Lp} W={Wp}
M10 net_e net_d VDD VDD PMOS_CI2N L={Lp} W={Wp}
M11 net_f net_f net_d net_d PMOS_CI2N L={Lp} W={Wp}
M12 Vout net_f net_e net_e PMOS_CI2N L={Lp} W={Wp}
M13 net_f net_p n3 n3 NMOS_CI2N L={Ln} W={Wn}
M14 Vout net_p n2 n2 NMOS_CI2N L={Ln} W={Wn}
M15 n3 net_b 0 0 NMOS_CI2N L={Ln} W={Wn}
M16 n2 net_b 0 0 NMOS_CI2N L={Ln} W={Wn}
C1 Vout 0 {Cval}
* supply rails (added; not part of the CI2N netlist)
Vsup_VDD VDD 0 {VDD}
.op
.end
