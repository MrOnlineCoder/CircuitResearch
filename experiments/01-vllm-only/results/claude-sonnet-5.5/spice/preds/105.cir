* CI2N circuit from experiments/01-vllm-only/results/claude-sonnet-5.5/preds/105.json
* generated by ci2n_to_spice.py
* renamed nets: Vin+ -> Vin_p, Vin- -> Vin_n, Vout- -> Vout_n, Vout+ -> Vout_p
* ---- placeholder values: CI2N netlists carry topology only; edit as needed ----
.param VDD=1.8 VSS=0
.param Rval=10k Cval=1p Ival=10u Vval=0.9
.param Wn=1u Ln=180n Wp=2u Lp=180n Aol=1e5
.model NMOS_CI2N NMOS (level=1 VTO=0.45 KP=200u LAMBDA=0.05)
.model PMOS_CI2N PMOS (level=1 VTO=-0.45 KP=80u LAMBDA=0.05)
.model NPN_CI2N NPN (Is=1e-16 Bf=100 Vaf=50)
.model PNP_CI2N PNP (Is=1e-16 Bf=50 Vaf=50)
.model D_CI2N D (Is=1e-14)

.subckt DIDO_AMP inp inn outp outn
E1 outp 0 inp inn {Aol/2}
E2 outn 0 inn inp {Aol/2}
.ends DIDO_AMP

M1 net1 V1 VDD VDD PMOS_CI2N L={Lp} W={Wp}
M2 net2 Vin_p net1 net1 NMOS_CI2N L={Ln} W={Wn}
M3 net3 Vin_n net1 net1 NMOS_CI2N L={Ln} W={Wn}
M4 net4 V2 VDD VDD PMOS_CI2N L={Lp} W={Wp}
M5 net5 V2 VDD VDD PMOS_CI2N L={Lp} W={Wp}
M6 Vout_n net6 net4 net4 PMOS_CI2N L={Lp} W={Wp}
M7 Vout_p net7 net5 net5 PMOS_CI2N L={Lp} W={Wp}
M8 Vout_n net8 net2 net2 NMOS_CI2N L={Ln} W={Wn}
M9 Vout_p net9 net3 net3 NMOS_CI2N L={Ln} W={Wn}
M10 net2 VCMFB 0 0 NMOS_CI2N L={Ln} W={Wn}
M11 net3 VCMFB 0 0 NMOS_CI2N L={Ln} W={Wn}
X1 net5 net4 net7 net6 DIDO_AMP
X2 net3 net2 net9 net8 DIDO_AMP
* supply rails (added; not part of the CI2N netlist)
Vsup_VDD VDD 0 {VDD}
.op
.end
