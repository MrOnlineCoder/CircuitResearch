* CI2N circuit from experiments/01-vllm-only/results/claude-sonnet-5.5/preds/040.json
* generated by ci2n_to_spice.py
* renamed nets: Vin- -> Vin_n, Vin+ -> Vin_p
* ---- placeholder values: CI2N netlists carry topology only; edit as needed ----
.param VDD=1.8 VSS=0
.param Rval=10k Cval=1p Ival=10u Vval=0.9
.param Wn=1u Ln=180n Wp=2u Lp=180n Aol=1e5
.model NMOS_CI2N NMOS (level=1 VTO=0.45 KP=200u LAMBDA=0.05)
.model PMOS_CI2N PMOS (level=1 VTO=-0.45 KP=80u LAMBDA=0.05)
.model NPN_CI2N NPN (Is=1e-16 Bf=100 Vaf=50)
.model PNP_CI2N PNP (Is=1e-16 Bf=50 Vaf=50)
.model D_CI2N D (Is=1e-14)

M1 BNcas VB VDD VDD PMOS_CI2N L={Lp} W={Wp}
R1 BNcas BN {Rval}
M2 BN BNcas nb1 nb1 NMOS_CI2N L={Ln} W={Wn}
M3 nb1 BN 0 0 NMOS_CI2N L={Ln} W={Wn}
M4 nb3 BP VDD VDD PMOS_CI2N L={Lp} W={Wp}
M5 BP BPcas nb3 nb3 PMOS_CI2N L={Lp} W={Wp}
R2 BP BPcas {Rval}
M6 BPcas BNcas nb2 nb2 NMOS_CI2N L={Ln} W={Wn}
M7 nb2 BN 0 0 NMOS_CI2N L={Ln} W={Wn}
M8 na1 BP VDD VDD PMOS_CI2N L={Lp} W={Wp}
M9 tail BPcas na1 na1 PMOS_CI2N L={Lp} W={Wp}
M10 nR Vin_n tail tail PMOS_CI2N L={Lp} W={Wp}
M11 nL Vin_p tail tail PMOS_CI2N L={Lp} W={Wp}
M12 nL BN 0 0 NMOS_CI2N L={Ln} W={Wn}
M13 nX Ncas nL nL NMOS_CI2N L={Ln} W={Wn}
M14 nR BN 0 0 NMOS_CI2N L={Ln} W={Wn}
M15 Vout Ncas nR nR NMOS_CI2N L={Ln} W={Wn}
M16 na5 nX VDD VDD PMOS_CI2N L={Lp} W={Wp}
M17 nX BPcas na5 na5 PMOS_CI2N L={Lp} W={Wp}
M18 na7 nX VDD VDD PMOS_CI2N L={Lp} W={Wp}
M19 Vout BPcas na7 na7 PMOS_CI2N L={Lp} W={Wp}
* supply rails (added; not part of the CI2N netlist)
Vsup_VDD VDD 0 {VDD}
.op
.end
