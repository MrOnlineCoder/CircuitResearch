* CI2N circuit from experiments/01-vllm-only/results/claude-sonnet-5.5/preds/062.json
* generated by ci2n_to_spice.py
* ---- placeholder values: CI2N netlists carry topology only; edit as needed ----
.param VDD=1.8 VSS=0
.param Rval=10k Cval=1p Ival=10u Vval=0.9
.param Wn=1u Ln=180n Wp=2u Lp=180n Aol=1e5
.model NMOS_CI2N NMOS (level=1 VTO=0.45 KP=200u LAMBDA=0.05)
.model PMOS_CI2N PMOS (level=1 VTO=-0.45 KP=80u LAMBDA=0.05)
.model NPN_CI2N NPN (Is=1e-16 Bf=100 Vaf=50)
.model PNP_CI2N PNP (Is=1e-16 Bf=50 Vaf=50)
.model D_CI2N D (Is=1e-14)

I1 VDD nb {Ival}
M1 nb nb VSS VSS NMOS_CI2N L={Ln} W={Wn}
M2 tail nb VSS VSS NMOS_CI2N L={Ln} W={Wn}
M3 d1 VIN tail tail NMOS_CI2N L={Ln} W={Wn}
M4 f tail tail tail NMOS_CI2N L={Ln} W={Wn}
R1 d1 a {Rval}
M5 n6 a VDD VDD PMOS_CI2N L={Lp} W={Wp}
M6 a d1 n6 n6 PMOS_CI2N L={Lp} W={Wp}
M7 n9 a VDD VDD PMOS_CI2N L={Lp} W={Wp}
M8 out1 d1 n9 n9 PMOS_CI2N L={Lp} W={Wp}
M9 n8 e VDD VDD PMOS_CI2N L={Lp} W={Wp}
M10 e f n8 n8 PMOS_CI2N L={Lp} W={Wp}
R2 e f {Rval}
M11 n11 e VDD VDD PMOS_CI2N L={Lp} W={Wp}
M12 g f n11 n11 PMOS_CI2N L={Lp} W={Wp}
C1 out1 0 {Cval}
M13 out1 g j j NMOS_CI2N L={Ln} W={Wn}
M14 j i VSS VSS NMOS_CI2N L={Ln} W={Wn}
R3 g h {Rval}
M15 h g i i NMOS_CI2N L={Ln} W={Wn}
M16 i i VSS VSS NMOS_CI2N L={Ln} W={Wn}
M17 k a VDD VDD PMOS_CI2N L={Lp} W={Wp}
M18 VSS out1 k VDD PMOS_CI2N L={Lp} W={Wp}
M19 VDD out1 m VSS NMOS_CI2N L={Ln} W={Wn}
M20 m i VSS VSS NMOS_CI2N L={Ln} W={Wn}
M21 VDD k VOUT VSS NMOS_CI2N L={Ln} W={Wn}
M22 VSS m VOUT VDD PMOS_CI2N L={Lp} W={Wp}
C2 VOUT 0 {Cval}
* supply rails (added; not part of the CI2N netlist)
Vsup_VDD VDD 0 {VDD}
Vsup_VSS VSS 0 {VSS}
.op
.end
