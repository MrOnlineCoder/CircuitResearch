* CI2N circuit from experiments/01-vllm-only/results/claude-sonnet-5.5/preds/072.json
* generated by ci2n_to_spice.py
* renamed nets: V- -> V_n, V+ -> V_p
* ---- placeholder values: CI2N netlists carry topology only; edit as needed ----
.param VDD=1.8 VSS=0
.param Rval=10k Cval=1p Ival=10u Vval=0.9
.param Wn=1u Ln=180n Wp=2u Lp=180n Aol=1e5
.model NMOS_CI2N NMOS (level=1 VTO=0.45 KP=200u LAMBDA=0.05)
.model PMOS_CI2N PMOS (level=1 VTO=-0.45 KP=80u LAMBDA=0.05)
.model NPN_CI2N NPN (Is=1e-16 Bf=100 Vaf=50)
.model PNP_CI2N PNP (Is=1e-16 Bf=50 Vaf=50)
.model D_CI2N D (Is=1e-14)

Q1 net1 V_n net3 NPN_CI2N
Q2 net2 V_p net3 NPN_CI2N
Q3 net1 net4 VDD PNP_CI2N
Q4 net2 net4 VDD PNP_CI2N
Q5 0 net1 net4 PNP_CI2N
Q6 VOUT net2 VDD PNP_CI2N
Q7 net3 VB VSS NPN_CI2N
Q8 VOUT VB VSS NPN_CI2N
* supply rails (added; not part of the CI2N netlist)
Vsup_VDD VDD 0 {VDD}
Vsup_VSS VSS 0 {VSS}
.op
.end
