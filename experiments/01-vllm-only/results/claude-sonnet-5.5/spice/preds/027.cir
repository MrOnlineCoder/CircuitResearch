* CI2N circuit from experiments/01-vllm-only/results/claude-sonnet-5.5/preds/027.json
* generated by ci2n_to_spice.py
* ---- placeholder values: CI2N netlists carry topology only; edit as needed ----
.param VDD=1.8 VSS=0
.param Rval=10k Cval=1p Ival=10u Vval=0.9
.param Wn=1u Ln=180n Wp=2u Lp=180n Aol=1e5
.model NMOS_CI2N NMOS (level=1 VTO=0.45 KP=200u LAMBDA=0.05)
.model PMOS_CI2N PMOS (level=1 VTO=-0.45 KP=80u LAMBDA=0.05)
.model NPN_CI2N NPN (Is=1e-16 Bf=100 Vaf=50)
.model PNP_CI2N PNP (Is=1e-16 Bf=50 Vaf=50)
.model D_CI2N D (Is=1e-14)

M1 net6 net1 VDD VDD PMOS_CI2N L={Lp} W={Wp}
M2 net7 net1 VDD VDD PMOS_CI2N L={Lp} W={Wp}
M3 net8 net1 VDD VDD PMOS_CI2N L={Lp} W={Wp}
M4 net9 net1 VDD VDD PMOS_CI2N L={Lp} W={Wp}
M5 net3 net2 net6 net6 PMOS_CI2N L={Lp} W={Wp}
M6 net1 net2 net7 net7 PMOS_CI2N L={Lp} W={Wp}
M7 net2 net2 VDD VDD PMOS_CI2N L={Lp} W={Wp}
M8 net4 net2 net8 net8 PMOS_CI2N L={Lp} W={Wp}
M9 SOURCE net2 net9 net9 PMOS_CI2N L={Lp} W={Wp}
M10 net3 net3 0 0 NMOS_CI2N L={Ln} W={Wn}
M11 net1 net3 net13 net13 NMOS_CI2N L={Ln} W={Wn}
R1 net13 0 {Rval}
R2 net4 net5 {Rval}
M12 net2 net4 net10 net10 NMOS_CI2N L={Ln} W={Wn}
M13 net5 net4 net11 net11 NMOS_CI2N L={Ln} W={Wn}
M14 SINK net4 net12 net12 NMOS_CI2N L={Ln} W={Wn}
M15 net10 net5 0 0 NMOS_CI2N L={Ln} W={Wn}
M16 net11 net5 0 0 NMOS_CI2N L={Ln} W={Wn}
M17 net12 net5 0 0 NMOS_CI2N L={Ln} W={Wn}
* supply rails (added; not part of the CI2N netlist)
Vsup_VDD VDD 0 {VDD}
.op
.end
