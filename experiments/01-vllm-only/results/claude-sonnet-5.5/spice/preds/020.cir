* CI2N circuit from experiments/01-vllm-only/results/claude-sonnet-5.5/preds/020.json
* generated by ci2n_to_spice.py
* ---- placeholder values: CI2N netlists carry topology only; edit as needed ----
.param VDD=1.8 VSS=0
.param Rval=10k Cval=1p Ival=10u Vval=0.9
.param Wn=1u Ln=180n Wp=2u Lp=180n Aol=1e5
.model NMOS_CI2N NMOS (level=1 VTO=0.45 KP=200u LAMBDA=0.05)
.model PMOS_CI2N PMOS (level=1 VTO=-0.45 KP=80u LAMBDA=0.05)
.model NPN_CI2N NPN (Is=1e-16 Bf=100 Vaf=50)
.model PNP_CI2N PNP (Is=1e-16 Bf=50 Vaf=50)
.model D_CI2N D (Is=1e-14)

M1 net1 Vb4 VDD VDD PMOS_CI2N L={Lp} W={Wp}
M2 Vin Vin_g net1 net1 NMOS_CI2N L={Ln} W={Wn}
M3 Vip Vip_g net1 net1 NMOS_CI2N L={Ln} W={Wn}
M4 net2 Vb3 VDD VDD PMOS_CI2N L={Lp} W={Wp}
M5 Vin Vb2 net2 net2 PMOS_CI2N L={Lp} W={Wp}
M6 net3 Vb3 VDD VDD PMOS_CI2N L={Lp} W={Wp}
M7 Vip Vb2 net3 net3 PMOS_CI2N L={Lp} W={Wp}
M8 Vin Vb1 net4 net4 NMOS_CI2N L={Ln} W={Wn}
M9 net4 Vc1 0 0 NMOS_CI2N L={Ln} W={Wn}
M10 Vip Vb1 net5 net5 NMOS_CI2N L={Ln} W={Wn}
M11 net5 Vc1 0 0 NMOS_CI2N L={Ln} W={Wn}
M12 Voutn Vc2 VDD VDD NMOS_CI2N L={Ln} W={Wn}
M13 Voutp Vc2 VDD VDD NMOS_CI2N L={Ln} W={Wn}
M14 Voutn Vin 0 0 NMOS_CI2N L={Ln} W={Wn}
M15 Voutp Vip 0 0 NMOS_CI2N L={Ln} W={Wn}
C1 Voutn Vin {Cval}
C2 Voutp Vip {Cval}
M16 Vin Voutn 0 0 NMOS_CI2N L={Ln} W={Wn}
M17 Vip Voutp 0 0 NMOS_CI2N L={Ln} W={Wn}
* supply rails (added; not part of the CI2N netlist)
Vsup_VDD VDD 0 {VDD}
.op
.end
