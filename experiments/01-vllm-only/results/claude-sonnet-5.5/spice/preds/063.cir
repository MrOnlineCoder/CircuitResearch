* CI2N circuit from experiments/01-vllm-only/results/claude-sonnet-5.5/preds/063.json
* generated by ci2n_to_spice.py
* ---- placeholder values: CI2N netlists carry topology only; edit as needed ----
.param VDD=1.8 VSS=0
.param Rval=10k Cval=1p Ival=10u Vval=0.9
.param Wn=1u Ln=180n Wp=2u Lp=180n Aol=1e5
.model NMOS_CI2N NMOS (level=1 VTO=0.45 KP=200u LAMBDA=0.05)
.model PMOS_CI2N PMOS (level=1 VTO=-0.45 KP=80u LAMBDA=0.05)
.model NPN_CI2N NPN (Is=1e-16 Bf=100 Vaf=50)
.model PNP_CI2N PNP (Is=1e-16 Bf=50 Vaf=50)
.model D_CI2N D (Is=1e-14)

M1 Vout1 VB1 VDD VDD PMOS_CI2N L={Lp} W={Wp}
M2 net1 VB1 VDD VDD PMOS_CI2N L={Lp} W={Wp}
M3 Vout2 VB1 VDD VDD PMOS_CI2N L={Lp} W={Wp}
M4 net2 Vin2 net1 net1 NMOS_CI2N L={Ln} W={Wn}
M5 net3 Vin1 net1 net1 NMOS_CI2N L={Ln} W={Wn}
M6 net2 net4 0 0 NMOS_CI2N L={Ln} W={Wn}
M7 net3 net4 0 0 NMOS_CI2N L={Ln} W={Wn}
M8 Vout1 net5 0 0 NMOS_CI2N L={Ln} W={Wn}
M9 Vout2 net6 0 0 NMOS_CI2N L={Ln} W={Wn}
C1 Vout1 net7 {Cval}
M10 net7 VB1 net2 net2 NMOS_CI2N L={Ln} W={Wn}
C2 Vout2 net8 {Cval}
M11 net8 VB1 net3 net3 NMOS_CI2N L={Ln} W={Wn}
R1 Vout1 net9 {Rval}
R2 Vout2 net9 {Rval}
M12 net10 VB1 VDD VDD PMOS_CI2N L={Lp} W={Wp}
M13 net11 net9 net10 net10 NMOS_CI2N L={Ln} W={Wn}
M14 net12 VB5 net10 net10 NMOS_CI2N L={Ln} W={Wn}
M15 net11 net11 0 0 NMOS_CI2N L={Ln} W={Wn}
M16 net12 net11 0 0 NMOS_CI2N L={Ln} W={Wn}
* supply rails (added; not part of the CI2N netlist)
Vsup_VDD VDD 0 {VDD}
.op
.end
