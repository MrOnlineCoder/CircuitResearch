* CI2N circuit from experiments/01-vllm-only/results/claude-sonnet-5.5/preds/097.json
* generated by ci2n_to_spice.py
* renamed nets: Vin- -> Vin_n, Vin+ -> Vin_p
* ---- placeholder values: CI2N netlists carry topology only; edit as needed ----
.param VDD=1.8 VSS=0
.param Rval=10k Cval=1p Ival=10u Vval=0.9
.param Wn=1u Ln=180n Wp=2u Lp=180n Aol=1e5
.model NMOS_CI2N NMOS (level=1 VTO=0.45 KP=200u LAMBDA=0.05)
.model PMOS_CI2N PMOS (level=1 VTO=-0.45 KP=80u LAMBDA=0.05)
.model NPN_CI2N NPN (Is=1e-16 Bf=100 Vaf=50)
.model PNP_CI2N PNP (Is=1e-16 Bf=50 Vaf=50)
.model D_CI2N D (Is=1e-14)

I1 VDD net_ib1 {Ival}
M1 net_m3 net_m3 VDD VDD PMOS_CI2N L={Lp} W={Wp}
M2 V1 net_m3 VDD VDD PMOS_CI2N L={Lp} W={Wp}
M3 net_m3 Vin_n net_tail net_tail NMOS_CI2N L={Ln} W={Wn}
M4 V1 Vin_p net_tail net_tail NMOS_CI2N L={Ln} W={Wn}
M5 net_tail net_ib1 VSS VSS NMOS_CI2N L={Ln} W={Wn}
M6 net_ib1 net_ib1 VSS VSS NMOS_CI2N L={Ln} W={Wn}
M7 net_m9s net_ib1 VSS VSS NMOS_CI2N L={Ln} W={Wn}
M8 V1p VBP net_m6s net_m6s PMOS_CI2N L={Lp} W={Wp}
M9 net_m6s V1 VDD VDD PMOS_CI2N L={Lp} W={Wp}
M10 V1p VBN net_m9s net_m9s NMOS_CI2N L={Ln} W={Wn}
R1 V1 net_rc {Rval}
C1 net_rc V1p {Cval}
I2 VDD net_ib2 {Ival}
M11 net_ib2 net_ib2 VDD VDD PMOS_CI2N L={Lp} W={Wp}
M12 net_m12s net_ib2 VDD VDD PMOS_CI2N L={Lp} W={Wp}
M13 V2 net_ib2 net_m12s net_m12s PMOS_CI2N L={Lp} W={Wp}
M14 net_m11d net_m11d V1p V1p NMOS_CI2N L={Ln} W={Wn}
M15 V1p net_m11d net_ib2 net_ib2 PMOS_CI2N L={Lp} W={Wp}
M16 V2 net_m11d VSS VSS NMOS_CI2N L={Ln} W={Wn}
M17 VO V1 VDD VDD PMOS_CI2N L={Lp} W={Wp}
M18 VO V2 VSS VSS NMOS_CI2N L={Ln} W={Wn}
R2 VO 0 {Rval}
C2 VO 0 {Cval}
* supply rails (added; not part of the CI2N netlist)
Vsup_VDD VDD 0 {VDD}
Vsup_VSS VSS 0 {VSS}
.op
.end
