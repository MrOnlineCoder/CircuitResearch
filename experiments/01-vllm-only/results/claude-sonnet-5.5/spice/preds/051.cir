* CI2N circuit from experiments/01-vllm-only/results/claude-sonnet-5.5/preds/051.json
* generated by ci2n_to_spice.py
* ---- placeholder values: CI2N netlists carry topology only; edit as needed ----
.param VDD=1.8 VSS=0
.param Rval=10k Cval=1p Ival=10u Vval=0.9
.param Wn=1u Ln=180n Wp=2u Lp=180n Aol=1e5
.model NMOS_CI2N NMOS (level=1 VTO=0.45 KP=200u LAMBDA=0.05)
.model PMOS_CI2N PMOS (level=1 VTO=-0.45 KP=80u LAMBDA=0.05)
.model NPN_CI2N NPN (Is=1e-16 Bf=100 Vaf=50)
.model PNP_CI2N PNP (Is=1e-16 Bf=50 Vaf=50)
.model D_CI2N D (Is=1e-14)

M1 net_tail Vbp VDD VDD PMOS_CI2N L={Lp} W={Wp}
M2 net_j Vin net_tail net_tail PMOS_CI2N L={Lp} W={Wp}
M3 net_m Vip net_tail net_tail PMOS_CI2N L={Lp} W={Wp}
M4 net_j Vbn 0 0 NMOS_CI2N L={Ln} W={Wn}
M5 net_m Vbn 0 0 NMOS_CI2N L={Ln} W={Wn}
M6 net_p4 net_a VDD VDD PMOS_CI2N L={Lp} W={Wp}
M7 net_a net_a net_p4 net_p4 PMOS_CI2N L={Lp} W={Wp}
M8 net_d net_a VDD VDD PMOS_CI2N L={Lp} W={Wp}
M9 net_c net_c VDD VDD PMOS_CI2N L={Lp} W={Wp}
R1 net_c net_b {Rval}
I1 net_b 0 {Ival}
M10 net_e net_b net_d net_d PMOS_CI2N L={Lp} W={Wp}
M11 net_f net_g net_d net_d PMOS_CI2N L={Lp} W={Wp}
M12 net_a net_i net_j net_j NMOS_CI2N L={Ln} W={Wn}
I2 VDD net_i {Ival}
R2 net_i net_k {Rval}
M13 net_k net_k 0 0 NMOS_CI2N L={Ln} W={Wn}
M14 net_e net_n net_m net_m NMOS_CI2N L={Ln} W={Wn}
M15 net_f net_i net_m net_m NMOS_CI2N L={Ln} W={Wn}
M16 net_h net_h VDD VDD PMOS_CI2N L={Lp} W={Wp}
R3 net_h net_g {Rval}
M17 net_p11 Vbp VDD VDD PMOS_CI2N L={Lp} W={Wp}
M18 net_g net_e net_p11 net_p11 PMOS_CI2N L={Lp} W={Wp}
I3 net_g 0 {Ival}
M19 Vout net_e VDD VDD PMOS_CI2N L={Lp} W={Wp}
M20 Vout net_f 0 0 NMOS_CI2N L={Ln} W={Wn}
I4 VDD net_n {Ival}
R4 net_n net_o {Rval}
M21 net_o net_o 0 0 NMOS_CI2N L={Ln} W={Wn}
M22 net_n net_f net_q net_q NMOS_CI2N L={Ln} W={Wn}
M23 net_q Vbn 0 0 NMOS_CI2N L={Ln} W={Wn}
* supply rails (added; not part of the CI2N netlist)
Vsup_VDD VDD 0 {VDD}
.op
.end
