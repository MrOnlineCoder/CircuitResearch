* CI2N circuit from experiments/01-vllm-only/results/claude-sonnet-5.5/preds/054.json
* generated by ci2n_to_spice.py
* renamed nets: V- -> V_n, V+ -> V_p
* ---- placeholder values: CI2N netlists carry topology only; edit as needed ----
.param VDD=1.8 VSS=0
.param Rval=10k Cval=1p Ival=10u Vval=0.9
.param Wn=1u Ln=180n Wp=2u Lp=180n Aol=1e5
.model NMOS_CI2N NMOS (level=1 VTO=0.45 KP=200u LAMBDA=0.05)
.model PMOS_CI2N PMOS (level=1 VTO=-0.45 KP=80u LAMBDA=0.05)
.model NPN_CI2N NPN (Is=1e-16 Bf=100 Vaf=50)
.model PNP_CI2N PNP (Is=1e-16 Bf=50 Vaf=50)
.model D_CI2N D (Is=1e-14)

M1 n_b n_a VDD VDD PMOS_CI2N L={Lp} W={Wp}
M2 n_a n_a VDD VDD PMOS_CI2N L={Lp} W={Wp}
M3 n_f n_f VDD VDD PMOS_CI2N L={Lp} W={Wp}
M4 n_g n_f VDD VDD PMOS_CI2N L={Lp} W={Wp}
M5 n_d n_c n_b n_b PMOS_CI2N L={Lp} W={Wp}
M6 n_c n_c n_a n_a PMOS_CI2N L={Lp} W={Wp}
M7 n_h n_h n_f n_f PMOS_CI2N L={Lp} W={Wp}
M8 IO n_h n_g n_g PMOS_CI2N L={Lp} W={Wp}
M9 n_c V_n tail tail NMOS_CI2N L={Ln} W={Wn}
M10 n_h V_p tail tail NMOS_CI2N L={Ln} W={Wn}
M11 Ibias Ibias VSS VSS NMOS_CI2N L={Ln} W={Wn}
M12 tail Ibias VSS VSS NMOS_CI2N L={Ln} W={Wn}
M13 n_d n_d n_e n_e NMOS_CI2N L={Ln} W={Wn}
M14 IO n_d n_i n_i NMOS_CI2N L={Ln} W={Wn}
M15 n_e n_e VSS VSS NMOS_CI2N L={Ln} W={Wn}
M16 n_i n_e VSS VSS NMOS_CI2N L={Ln} W={Wn}
* supply rails (added; not part of the CI2N netlist)
Vsup_VDD VDD 0 {VDD}
Vsup_VSS VSS 0 {VSS}
.op
.end
