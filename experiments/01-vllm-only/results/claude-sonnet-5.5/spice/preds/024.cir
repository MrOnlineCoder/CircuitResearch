* CI2N circuit from experiments/01-vllm-only/results/claude-sonnet-5.5/preds/024.json
* generated by ci2n_to_spice.py
* ---- placeholder values: CI2N netlists carry topology only; edit as needed ----
.param VDD=1.8 VSS=0
.param Rval=10k Cval=1p Ival=10u Vval=0.9
.param Wn=1u Ln=180n Wp=2u Lp=180n Aol=1e5
.model NMOS_CI2N NMOS (level=1 VTO=0.45 KP=200u LAMBDA=0.05)
.model PMOS_CI2N PMOS (level=1 VTO=-0.45 KP=80u LAMBDA=0.05)
.model NPN_CI2N NPN (Is=1e-16 Bf=100 Vaf=50)
.model PNP_CI2N PNP (Is=1e-16 Bf=50 Vaf=50)
.model D_CI2N D (Is=1e-14)

M1 n1 Vp1 VDD VDD PMOS_CI2N L={Lp} W={Wp}
M2 n2 Vp1 VDD VDD PMOS_CI2N L={Lp} W={Wp}
M3 n3 Vp1 VDD VDD PMOS_CI2N L={Lp} W={Wp}
M4 B Vp2 n1 n1 PMOS_CI2N L={Lp} W={Wp}
M5 A Vp2 n2 n2 PMOS_CI2N L={Lp} W={Wp}
M6 Vref Vp2 n3 n3 PMOS_CI2N L={Lp} W={Wp}
R1 Vref 0 {Rval}
R2 A C {Rval}
R3 C 0 {Rval}
R4 B D {Rval}
R5 D 0 {Rval}
R6 B nq2 {Rval}
Q1 0 0 A PNP_CI2N
Q2 0 0 nq2 PNP_CI2N
M7 Vp1 Vb21 VDD VDD PMOS_CI2N L={Lp} W={Wp}
M8 ntail Vb21 VDD VDD PMOS_CI2N L={Lp} W={Wp}
M9 Vb21 Vb21 VDD VDD PMOS_CI2N L={Lp} W={Wp}
M10 nout D ntail ntail PMOS_CI2N L={Lp} W={Wp}
M11 n24 C ntail ntail PMOS_CI2N L={Lp} W={Wp}
M12 nout n24 0 0 NMOS_CI2N L={Ln} W={Wn}
M13 n24 n24 0 0 NMOS_CI2N L={Ln} W={Wn}
M14 Vp1 nout 0 0 NMOS_CI2N L={Ln} W={Wn}
C1 Vp1 ncc {Cval}
R7 ncc nout {Rval}
M15 Vb21 nb19 0 0 NMOS_CI2N L={Ln} W={Wn}
M16 nb19 nb19 0 0 NMOS_CI2N L={Ln} W={Wn}
M17 n17 Vp1 VDD VDD PMOS_CI2N L={Lp} W={Wp}
M18 nb19 Vp2 n17 n17 PMOS_CI2N L={Lp} W={Wp}
M19 n7 Vp1 VDD VDD PMOS_CI2N L={Lp} W={Wp}
M20 nm8 Vp2 n7 n7 PMOS_CI2N L={Lp} W={Wp}
M21 nm8 nm8 0 0 NMOS_CI2N L={Ln} W={Wn}
M22 Vp2 nm8 0 0 NMOS_CI2N L={Ln} W={Wn}
M23 Vp2 Vp2 VDD VDD PMOS_CI2N L={Lp} W={Wp}
M24 nst Vp2 0 0 NMOS_CI2N L={Ln} W={Wn}
M25 nst Vp1 0 0 NMOS_CI2N L={Ln} W={Wn}
M26 nst nm8 0 0 NMOS_CI2N L={Ln} W={Wn}
M27 n10 0 VDD VDD PMOS_CI2N L={Lp} W={Wp}
M28 nst 0 n10 n10 PMOS_CI2N L={Lp} W={Wp}
* supply rails (added; not part of the CI2N netlist)
Vsup_VDD VDD 0 {VDD}
.op
.end
