* CI2N circuit from experiments/01-vllm-only/results/claude-sonnet-5.5/preds/077.json
* generated by ci2n_to_spice.py
* ---- placeholder values: CI2N netlists carry topology only; edit as needed ----
.param VDD=1.8 VSS=0
.param Rval=10k Cval=1p Ival=10u Vval=0.9
.param Wn=1u Ln=180n Wp=2u Lp=180n Aol=1e5
.model NMOS_CI2N NMOS (level=1 VTO=0.45 KP=200u LAMBDA=0.05)
.model PMOS_CI2N PMOS (level=1 VTO=-0.45 KP=80u LAMBDA=0.05)
.model NPN_CI2N NPN (Is=1e-16 Bf=100 Vaf=50)
.model PNP_CI2N PNP (Is=1e-16 Bf=50 Vaf=50)
.model D_CI2N D (Is=1e-14)

Q1 VDD NONINV net_e1 NPN_CI2N
Q2 VDD INV net_e2 NPN_CI2N
Q3 net_q3c net_b34 net_e1 PNP_CI2N
Q4 net_q4c net_b34 net_e2 PNP_CI2N
Q5 net_q3c net_q56b OFFSET_NULL1 NPN_CI2N
Q6 net_q4c net_q56b OFFSET_NULL2 NPN_CI2N
Q7 VDD net_q3c net_q56b NPN_CI2N
Q8 net_c1 net_c1 VDD PNP_CI2N
Q9 net_b34 net_c1 VDD PNP_CI2N
Q10 net_b34 net_q11c net_r4 NPN_CI2N
Q11 net_q11c net_q11c VSS NPN_CI2N
Q12 net_q12c net_q12c VDD PNP_CI2N
Q13 net_c13 net_q12c VDD PNP_CI2N
Q14 VDD net_c13 net_q14e NPN_CI2N
Q15 net_c13 net_q14e OUTPUT NPN_CI2N
Q16 net_c13 net_q18b net_q18e NPN_CI2N
Q17 net_q18e net_q4c net_q16e NPN_CI2N
Q18 net_q18e net_q16e net_q17e NPN_CI2N
Q19 net_q4c net_q17e VSS NPN_CI2N
Q20 VSS net_q18e net_r10 PNP_CI2N
R1 OFFSET_NULL1 VSS {Rval}
R2 net_q56b VSS {Rval}
R3 OFFSET_NULL2 VSS {Rval}
R4 net_r4 VSS {Rval}
R5 net_q12c net_q11c {Rval}
R6 net_c13 net_q18b {Rval}
R7 net_q18b net_q18e {Rval}
R8 net_q14e OUTPUT {Rval}
R9 OUTPUT net_r10 {Rval}
R10 net_q16e VSS {Rval}
R11 net_q17e VSS {Rval}
C1 net_c13 net_q4c {Cval}
* supply rails (added; not part of the CI2N netlist)
Vsup_VDD VDD 0 {VDD}
Vsup_VSS VSS 0 {VSS}
.op
.end
