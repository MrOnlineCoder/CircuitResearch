* CI2N circuit from experiments/01-vllm-only/results/claude-sonnet-5.5/preds/073.json
* generated by ci2n_to_spice.py
* ---- placeholder values: CI2N netlists carry topology only; edit as needed ----
.param VDD=1.8 VSS=0
.param Rval=10k Cval=1p Ival=10u Vval=0.9
.param Wn=1u Ln=180n Wp=2u Lp=180n Aol=1e5
.model NMOS_CI2N NMOS (level=1 VTO=0.45 KP=200u LAMBDA=0.05)
.model PMOS_CI2N PMOS (level=1 VTO=-0.45 KP=80u LAMBDA=0.05)
.model NPN_CI2N NPN (Is=1e-16 Bf=100 Vaf=50)
.model PNP_CI2N PNP (Is=1e-16 Bf=50 Vaf=50)
.model D_CI2N D (Is=1e-14)

M1 ntail Vtail VDD VDD PMOS_CI2N L={Lp} W={Wp}
M2 na VinP ntail ntail NMOS_CI2N L={Ln} W={Wn}
M3 nb VinN ntail ntail NMOS_CI2N L={Ln} W={Wn}
M4 na Vcmfb 0 0 NMOS_CI2N L={Ln} W={Wn}
M5 nb Vcmfb 0 0 NMOS_CI2N L={Ln} W={Wn}
M6 nc Vbm VDD VDD PMOS_CI2N L={Lp} W={Wp}
M7 VoutN VcascP nc nc PMOS_CI2N L={Lp} W={Wp}
M8 VoutN Vbp na na NMOS_CI2N L={Ln} W={Wn}
M9 nd Vbm VDD VDD PMOS_CI2N L={Lp} W={Wp}
M10 VoutP VcascP nd nd PMOS_CI2N L={Lp} W={Wp}
M11 VoutP Vbp nb nb NMOS_CI2N L={Ln} W={Wn}
M12 nS7 nS7 VDD VDD PMOS_CI2N L={Lp} W={Wp}
M13 VoutN nS7 VDD VDD PMOS_CI2N L={Lp} W={Wp}
M14 nS8 nS8 VDD VDD PMOS_CI2N L={Lp} W={Wp}
M15 VoutP nS8 VDD VDD PMOS_CI2N L={Lp} W={Wp}
M16 nS7 na 0 0 NMOS_CI2N L={Ln} W={Wn}
M17 VoutP na 0 0 NMOS_CI2N L={Ln} W={Wn}
M18 na na 0 0 NMOS_CI2N L={Ln} W={Wn}
M19 nb nb 0 0 NMOS_CI2N L={Ln} W={Wn}
M20 VoutN nb 0 0 NMOS_CI2N L={Ln} W={Wn}
M21 nS8 nb 0 0 NMOS_CI2N L={Ln} W={Wn}
C1 VoutN 0 {Cval}
C2 VoutP 0 {Cval}
* supply rails (added; not part of the CI2N netlist)
Vsup_VDD VDD 0 {VDD}
.op
.end
