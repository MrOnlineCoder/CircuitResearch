* CI2N circuit from experiments/01-vllm-only/results/claude-sonnet-5.5/preds/057.json
* generated by ci2n_to_spice.py
* renamed nets: Vout+ -> Vout_p, Vout- -> Vout_n, Vin- -> Vin_n, Vin+ -> Vin_p
* ---- placeholder values: CI2N netlists carry topology only; edit as needed ----
.param VDD=1.8 VSS=0
.param Rval=10k Cval=1p Ival=10u Vval=0.9
.param Wn=1u Ln=180n Wp=2u Lp=180n Aol=1e5
.model NMOS_CI2N NMOS (level=1 VTO=0.45 KP=200u LAMBDA=0.05)
.model PMOS_CI2N PMOS (level=1 VTO=-0.45 KP=80u LAMBDA=0.05)
.model NPN_CI2N NPN (Is=1e-16 Bf=100 Vaf=50)
.model PNP_CI2N PNP (Is=1e-16 Bf=50 Vaf=50)
.model D_CI2N D (Is=1e-14)

.subckt DIDO_AMP inp inn outp outn
E1 outp 0 inp inn {Aol/2}
E2 outn 0 inn inp {Aol/2}
.ends DIDO_AMP

X1 net2 net1 Vout_p Vout_n DIDO_AMP
C1 Vin_n net1 {Cval}
C2 Vin_p net2 {Cval}
C3 net1 Vout_p {Cval}
C4 net2 Vout_n {Cval}
C5 Vout_p 0 {Cval}
C6 Vout_n 0 {Cval}
.op
.end
