* CI2N circuit from experiments/01-vllm-only/results/claude-sonnet-5.5/preds/025.json
* generated by ci2n_to_spice.py
* ---- placeholder values: CI2N netlists carry topology only; edit as needed ----
.param VDD=1.8 VSS=0
.param Rval=10k Cval=1p Ival=10u Vval=0.9
.param Wn=1u Ln=180n Wp=2u Lp=180n Aol=1e5
.model NMOS_CI2N NMOS (level=1 VTO=0.45 KP=200u LAMBDA=0.05)
.model PMOS_CI2N PMOS (level=1 VTO=-0.45 KP=80u LAMBDA=0.05)
.model NPN_CI2N NPN (Is=1e-16 Bf=100 Vaf=50)
.model PNP_CI2N PNP (Is=1e-16 Bf=50 Vaf=50)
.model D_CI2N D (Is=1e-14)

.subckt DISO_AMP inp inn out
E1 out 0 inp inn {Aol}
.ends DISO_AMP

M1 net1 net3 VDD VDD PMOS_CI2N L={Lp} W={Wp}
M2 net2 net3 VDD VDD PMOS_CI2N L={Lp} W={Wp}
M3 Vout1 net3 VDD VDD PMOS_CI2N L={Lp} W={Wp}
R1 net1 Y {Rval}
R2 net2 X {Rval}
R3 Y net4 {Rval}
R4 Vout1 net5 {Rval}
Q1 0 0 net4 PNP_CI2N
Q2 0 0 X PNP_CI2N
Q3 0 0 net5 PNP_CI2N
X1 Y X net3 DISO_AMP
C1 VDD net3 {Cval}
M4 net3 net6 0 0 NMOS_CI2N L={Ln} W={Wn}
M5 net6 Vout1 0 0 NMOS_CI2N L={Ln} W={Wn}
M6 net6 net6 VDD VDD PMOS_CI2N L={Lp} W={Wp}
* supply rails (added; not part of the CI2N netlist)
Vsup_VDD VDD 0 {VDD}
.op
.end
