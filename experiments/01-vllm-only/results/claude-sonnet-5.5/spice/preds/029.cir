* CI2N circuit from experiments/01-vllm-only/results/claude-sonnet-5.5/preds/029.json
* generated by ci2n_to_spice.py
* ---- placeholder values: CI2N netlists carry topology only; edit as needed ----
.param VDD=1.8 VSS=0
.param Rval=10k Cval=1p Ival=10u Vval=0.9
.param Wn=1u Ln=180n Wp=2u Lp=180n Aol=1e5
.model NMOS_CI2N NMOS (level=1 VTO=0.45 KP=200u LAMBDA=0.05)
.model PMOS_CI2N PMOS (level=1 VTO=-0.45 KP=80u LAMBDA=0.05)
.model NPN_CI2N NPN (Is=1e-16 Bf=100 Vaf=50)
.model PNP_CI2N PNP (Is=1e-16 Bf=50 Vaf=50)
.model D_CI2N D (Is=1e-14)

M1 n1 VBP1 VDD VDD PMOS_CI2N L={Lp} W={Wp}
M2 n2 VBP1 VDD VDD PMOS_CI2N L={Lp} W={Wp}
M3 n3 VBP1 VDD VDD PMOS_CI2N L={Lp} W={Wp}
M4 VBN1 VBP2 n1 n1 PMOS_CI2N L={Lp} W={Wp}
M5 VBP1 VBP2 n2 n2 PMOS_CI2N L={Lp} W={Wp}
M6 Vref VBP2 n3 n3 PMOS_CI2N L={Lp} W={Wp}
M7 n4 VBP1 VDD VDD PMOS_CI2N L={Lp} W={Wp}
M8 n16 VBP2 n4 n4 PMOS_CI2N L={Lp} W={Wp}
M9 VBP2 VBP2 VDD VDD PMOS_CI2N L={Lp} W={Wp}
M10 n5 VBP1 VDD VDD PMOS_CI2N L={Lp} W={Wp}
M11 VBN2 VBP2 n5 n5 PMOS_CI2N L={Lp} W={Wp}
M12 VBP1 VBN1 n7 n7 NMOS_CI2N L={Ln} W={Wn}
M13 n7 VBN2 n8 n8 NMOS_CI2N L={Ln} W={Wn}
M14 VBN1 VBN1 n6 n6 NMOS_CI2N L={Ln} W={Wn}
M15 n6 VBN2 n10 n10 NMOS_CI2N L={Ln} W={Wn}
M16 n16 n16 0 0 NMOS_CI2N L={Ln} W={Wn}
M17 VBP2 n16 0 0 NMOS_CI2N L={Ln} W={Wn}
M18 VBN2 VBN2 n11 n11 NMOS_CI2N L={Ln} W={Wn}
M19 n12 0 VDD VDD PMOS_CI2N L={Lp} W={Wp}
M20 SU 0 n12 n12 PMOS_CI2N L={Lp} W={Wp}
M21 VBP2 SU 0 0 NMOS_CI2N L={Ln} W={Wn}
M22 VBP1 SU 0 0 NMOS_CI2N L={Ln} W={Wn}
M23 SU VBN1 0 0 NMOS_CI2N L={Ln} W={Wn}
Q1 n10 0 0 NPN_CI2N
Q2 n9 0 0 NPN_CI2N
Q3 n13 0 0 NPN_CI2N
Q4 n11 0 0 NPN_CI2N
R1 n8 n9 {Rval}
R2 Vref n13 {Rval}
* supply rails (added; not part of the CI2N netlist)
Vsup_VDD VDD 0 {VDD}
.op
.end
