* CI2N circuit from experiments/01-vllm-only/results/claude-sonnet-5.5/preds/075.json
* generated by ci2n_to_spice.py
* renamed nets: Vi- -> Vi_n, Vi+ -> Vi_p
* ---- placeholder values: CI2N netlists carry topology only; edit as needed ----
.param VDD=1.8 VSS=0
.param Rval=10k Cval=1p Ival=10u Vval=0.9
.param Wn=1u Ln=180n Wp=2u Lp=180n Aol=1e5
.model NMOS_CI2N NMOS (level=1 VTO=0.45 KP=200u LAMBDA=0.05)
.model PMOS_CI2N PMOS (level=1 VTO=-0.45 KP=80u LAMBDA=0.05)
.model NPN_CI2N NPN (Is=1e-16 Bf=100 Vaf=50)
.model PNP_CI2N PNP (Is=1e-16 Bf=50 Vaf=50)
.model D_CI2N D (Is=1e-14)

M1 nb1 nb1 VDD VDD PMOS_CI2N L={Lp} W={Wp}
M2 nb2 nb1 VDD VDD PMOS_CI2N L={Lp} W={Wp}
M3 nb3 nb3 nb1 nb1 PMOS_CI2N L={Lp} W={Wp}
M4 vbn nb3 nb2 nb2 PMOS_CI2N L={Lp} W={Wp}
M5 nb3 vbn nrb nrb NMOS_CI2N L={Ln} W={Wn}
M6 vbn vbn VSS VSS NMOS_CI2N L={Ln} W={Wn}
R1 nrb VSS {Rval}
M7 nd1 nd1 VDD VDD PMOS_CI2N L={Lp} W={Wp}
M8 no1 nd1 VDD VDD PMOS_CI2N L={Lp} W={Wp}
M9 nd1 Vi_n ntail ntail NMOS_CI2N L={Ln} W={Wn}
M10 no1 Vi_p ntail ntail NMOS_CI2N L={Ln} W={Wn}
M11 ntail vbn VSS VSS NMOS_CI2N L={Ln} W={Wn}
M12 nm1 nb6 VDD VDD PMOS_CI2N L={Lp} W={Wp}
M13 no1 nb6 VDD VDD PMOS_CI2N L={Lp} W={Wp}
M14 nb6 0 nm1 nm1 PMOS_CI2N L={Lp} W={Wp}
M15 nc 0 no1 no1 PMOS_CI2N L={Lp} W={Wp}
M16 nb6 vbn VSS VSS NMOS_CI2N L={Ln} W={Wn}
M17 nc vbn VSS VSS NMOS_CI2N L={Ln} W={Wn}
M18 Vout no1 VDD VDD PMOS_CI2N L={Lp} W={Wp}
M19 Vout vbn VSS VSS NMOS_CI2N L={Ln} W={Wn}
C1 nc Vout {Cval}
C2 Vout 0 {Cval}
* supply rails (added; not part of the CI2N netlist)
Vsup_VDD VDD 0 {VDD}
Vsup_VSS VSS 0 {VSS}
.op
.end
