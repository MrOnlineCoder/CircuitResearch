* CI2N circuit from experiments/01-vllm-only/results/claude-sonnet-5.5/golden/053.json
* ckt_type: DISO-Amplifier
* generated by ci2n_to_spice.py
* renamed nets: +1V -> _p1V, -1V -> _n1V
* ---- placeholder values: CI2N netlists carry topology only; edit as needed ----
.param VDD=1.8 VSS=0
.param Rval=10k Cval=1p Ival=10u Vval=0.9
.param Wn=1u Ln=180n Wp=2u Lp=180n Aol=1e5
.model NMOS_CI2N NMOS (level=1 VTO=0.45 KP=200u LAMBDA=0.05)
.model PMOS_CI2N PMOS (level=1 VTO=-0.45 KP=80u LAMBDA=0.05)
.model NPN_CI2N NPN (Is=1e-16 Bf=100 Vaf=50)
.model PNP_CI2N PNP (Is=1e-16 Bf=50 Vaf=50)
.model D_CI2N D (Is=1e-14)

M1 net4 net3 _p1V _p1V PMOS_CI2N L={Lp} W={Wp}
M2 net3 net2 _p1V _p1V PMOS_CI2N L={Lp} W={Wp}
M3 net2 net2 _p1V _p1V PMOS_CI2N L={Lp} W={Wp}
M4 net1 net1 _n1V _n1V NMOS_CI2N L={Ln} W={Wn}
M5 net5 net1 _n1V _n1V NMOS_CI2N L={Ln} W={Wn}
M6 net4 net1 _n1V _n1V NMOS_CI2N L={Ln} W={Wn}
M7 net3 net7 net5 net5 NMOS_CI2N L={Ln} W={Wn}
M8 net2 net6 net5 net5 NMOS_CI2N L={Ln} W={Wn}
C1 net4 0 {Cval}
C2 net3 net4 {Cval}
I1 _p1V net1 {Ival}
.op
.end
