* CI2N circuit from experiments/01-vllm-only/results/claude-sonnet-5.5/golden/115.json
* ckt_type: Bandgap
* generated by ci2n_to_spice.py
* ---- placeholder values: CI2N netlists carry topology only; edit as needed ----
.param VDD=1.8 VSS=0
.param Rval=10k Cval=1p Ival=10u Vval=0.9
.param Wn=1u Ln=180n Wp=2u Lp=180n Aol=1e5
.model NMOS_CI2N NMOS (level=1 VTO=0.45 KP=200u LAMBDA=0.05)
.model PMOS_CI2N PMOS (level=1 VTO=-0.45 KP=80u LAMBDA=0.05)
.model NPN_CI2N NPN (Is=1e-16 Bf=100 Vaf=50)
.model PNP_CI2N PNP (Is=1e-16 Bf=50 Vaf=50)
.model D_CI2N D (Is=1e-14)

.subckt DISO_AMP inp inn out
E1 out 0 inp inn {Aol}
.ends DISO_AMP

X1 net3 net2 net1 DISO_AMP
D1 net4 0 D_CI2N
D2 net3 0 D_CI2N
R1 net2 net4 {Rval}
M1 netx net1 VDD1 VDD1 PMOS_CI2N L={Lp} W={Wp}
M2 net3 net1 VDD2 VDD2 PMOS_CI2N L={Lp} W={Wp}
M3 net2 net1 VDD3 VDD3 PMOS_CI2N L={Lp} W={Wp}
* supply rails (added; not part of the CI2N netlist)
Vsup_VDD1 VDD1 0 {VDD}
Vsup_VDD2 VDD2 0 {VDD}
Vsup_VDD3 VDD3 0 {VDD}
.op
.end
