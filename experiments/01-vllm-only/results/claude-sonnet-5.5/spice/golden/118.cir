* CI2N circuit from experiments/01-vllm-only/results/claude-sonnet-5.5/golden/118.json
* ckt_type: Comparator
* generated by ci2n_to_spice.py
* renamed nets: CLK$2 -> CLK_2, CLK$3' -> CLK_3_, CLK$1 -> CLK_1
* ---- placeholder values: CI2N netlists carry topology only; edit as needed ----
.param VDD=1.8 VSS=0
.param Rval=10k Cval=1p Ival=10u Vval=0.9
.param Wn=1u Ln=180n Wp=2u Lp=180n Aol=1e5
.model NMOS_CI2N NMOS (level=1 VTO=0.45 KP=200u LAMBDA=0.05)
.model PMOS_CI2N PMOS (level=1 VTO=-0.45 KP=80u LAMBDA=0.05)
.model NPN_CI2N NPN (Is=1e-16 Bf=100 Vaf=50)
.model PNP_CI2N PNP (Is=1e-16 Bf=50 Vaf=50)
.model D_CI2N D (Is=1e-14)

M1 net2 CLK_2 VDD1 VDD1 PMOS_CI2N L={Lp} W={Wp}
M2 net3 CLK_2 VDD1 VDD1 PMOS_CI2N L={Lp} W={Wp}
M3 VOUT1 VOUT2 net1 net1 PMOS_CI2N L={Lp} W={Wp}
M4 VOUT2 VOUT1 net1 net1 PMOS_CI2N L={Lp} W={Wp}
M5 net1 CLK_3_ VDD2 VDD2 PMOS_CI2N L={Lp} W={Wp}
M6 net4 CLK_1 0 0 NMOS_CI2N L={Ln} W={Wn}
M7 net2 VIN1 net4 net4 NMOS_CI2N L={Ln} W={Wn}
M8 net3 VIN2 net4 net4 NMOS_CI2N L={Ln} W={Wn}
M9 VOUT1 net2 0 0 NMOS_CI2N L={Ln} W={Wn}
M10 VOUT2 net3 0 0 NMOS_CI2N L={Ln} W={Wn}
M11 VOUT1 VOUT2 0 0 NMOS_CI2N L={Ln} W={Wn}
M12 VOUT2 VOUT1 0 0 NMOS_CI2N L={Ln} W={Wn}
* supply rails (added; not part of the CI2N netlist)
Vsup_VDD1 VDD1 0 {VDD}
Vsup_VDD2 VDD2 0 {VDD}
.op
.end
