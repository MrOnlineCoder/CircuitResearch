* CI2N circuit from experiments/01-vllm-only/results/claude-sonnet-5.5/golden/121.json
* ckt_type: DIDO-Amplifier
* generated by ci2n_to_spice.py
* ---- placeholder values: CI2N netlists carry topology only; edit as needed ----
.param VDD=1.8 VSS=0
.param Rval=10k Cval=1p Ival=10u Vval=0.9
.param Wn=1u Ln=180n Wp=2u Lp=180n Aol=1e5
.model NMOS_CI2N NMOS (level=1 VTO=0.45 KP=200u LAMBDA=0.05)
.model PMOS_CI2N PMOS (level=1 VTO=-0.45 KP=80u LAMBDA=0.05)
.model NPN_CI2N NPN (Is=1e-16 Bf=100 Vaf=50)
.model PNP_CI2N PNP (Is=1e-16 Bf=50 Vaf=50)
.model D_CI2N D (Is=1e-14)

M1 G Vp2 net4 net4 PMOS_CI2N L={Lp} W={Wp}
M2 net4 Vp1 VDD VDD PMOS_CI2N L={Lp} W={Wp}
M3 H Vp2 net5 net5 PMOS_CI2N L={Lp} W={Wp}
M4 net5 Vp1 VDD VDD PMOS_CI2N L={Lp} W={Wp}
M5 net2 VEFset net1 net1 PMOS_CI2N L={Lp} W={Wp}
M6 net6 E net1 net1 PMOS_CI2N L={Lp} W={Wp}
M7 net7 F net1 net1 PMOS_CI2N L={Lp} W={Wp}
M8 net1 Vp2 net3 net3 PMOS_CI2N L={Lp} W={Wp}
M9 net3 Vp1 VDD VDD PMOS_CI2N L={Lp} W={Wp}
M10 net6 Vn2 0 0 NMOS_CI2N L={Ln} W={Wn}
M11 G Vn1 net6 net6 NMOS_CI2N L={Ln} W={Wn}
M12 net7 Vn2 0 0 NMOS_CI2N L={Ln} W={Wn}
M13 H Vn1 net7 net7 NMOS_CI2N L={Ln} W={Wn}
R1 net2 0 {Rval}
* supply rails (added; not part of the CI2N netlist)
Vsup_VDD VDD 0 {VDD}
.op
.end
