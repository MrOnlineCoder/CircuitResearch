* CI2N circuit from experiments/01-vllm-only/results/claude-sonnet-5.5/golden/063.json
* ckt_type: DIDO-Amplifier
* generated by ci2n_to_spice.py
* ---- placeholder values: CI2N netlists carry topology only; edit as needed ----
.param VDD=1.8 VSS=0
.param Rval=10k Cval=1p Ival=10u Vval=0.9
.param Wn=1u Ln=180n Wp=2u Lp=180n Aol=1e5
.model NMOS_CI2N NMOS (level=1 VTO=0.45 KP=200u LAMBDA=0.05)
.model PMOS_CI2N PMOS (level=1 VTO=-0.45 KP=80u LAMBDA=0.05)
.model NPN_CI2N NPN (Is=1e-16 Bf=100 Vaf=50)
.model PNP_CI2N PNP (Is=1e-16 Bf=50 Vaf=50)
.model D_CI2N D (Is=1e-14)

M1 net17 net17 0 0 NMOS_CI2N L={Ln} W={Wn}
M2 net13 net13 0 0 NMOS_CI2N L={Ln} W={Wn}
M3 net3 net6 0 0 NMOS_CI2N L={Ln} W={Wn}
M4 net6 net13 0 0 NMOS_CI2N L={Ln} W={Wn}
M5 net5 net13 0 0 NMOS_CI2N L={Ln} W={Wn}
M6 net1 net5 0 0 NMOS_CI2N L={Ln} W={Wn}
M7 net12 net11 net6 net6 NMOS_CI2N L={Ln} W={Wn}
M8 net7 net10 net5 net5 NMOS_CI2N L={Ln} W={Wn}
M9 net2 net4 VDD VDD PMOS_CI2N L={Lp} W={Wp}
M10 net17 net18 net15 net15 PMOS_CI2N L={Lp} W={Wp}
M11 net13 net16 net15 net15 PMOS_CI2N L={Lp} W={Wp}
M12 net15 net14 VDD1 VDD1 PMOS_CI2N L={Lp} W={Wp}
M13 net6 net8 net2 net2 PMOS_CI2N L={Lp} W={Wp}
M14 net5 net9 net2 net2 PMOS_CI2N L={Lp} W={Wp}
M15 net3 net4 VDD VDD PMOS_CI2N L={Lp} W={Wp}
M16 net1 net4 VDD VDD PMOS_CI2N L={Lp} W={Wp}
R1 net16 net3 {Rval}
R2 net16 net1 {Rval}
C1 net12 net3 {Cval}
C2 net1 net7 {Cval}
* supply rails (added; not part of the CI2N netlist)
Vsup_VDD VDD 0 {VDD}
Vsup_VDD1 VDD1 0 {VDD}
.op
.end
