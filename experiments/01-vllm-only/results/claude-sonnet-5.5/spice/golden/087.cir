* CI2N circuit from experiments/01-vllm-only/results/claude-sonnet-5.5/golden/087.json
* ckt_type: DISO-Amplifier
* generated by ci2n_to_spice.py
* renamed nets: Vin+ -> Vin_p, Vin- -> Vin_n
* ---- placeholder values: CI2N netlists carry topology only; edit as needed ----
.param VDD=1.8 VSS=0
.param Rval=10k Cval=1p Ival=10u Vval=0.9
.param Wn=1u Ln=180n Wp=2u Lp=180n Aol=1e5
.model NMOS_CI2N NMOS (level=1 VTO=0.45 KP=200u LAMBDA=0.05)
.model PMOS_CI2N PMOS (level=1 VTO=-0.45 KP=80u LAMBDA=0.05)
.model NPN_CI2N NPN (Is=1e-16 Bf=100 Vaf=50)
.model PNP_CI2N PNP (Is=1e-16 Bf=50 Vaf=50)
.model D_CI2N D (Is=1e-14)

M1 net32 Vin_p net19 net19 NMOS_CI2N L={Ln} W={Wn}
M2 net41 net22 0 0 NMOS_CI2N L={Ln} W={Wn}
M3 OUT net23 net41 net41 NMOS_CI2N L={Ln} W={Wn}
M4 net28 net23 net37 net37 NMOS_CI2N L={Ln} W={Wn}
M5 net35 net24 0 0 NMOS_CI2N L={Ln} W={Wn}
M6 net44 net22 0 0 NMOS_CI2N L={Ln} W={Wn}
M7 net22 net23 net44 net44 NMOS_CI2N L={Ln} W={Wn}
M8 net48 net10 0 0 NMOS_CI2N L={Ln} W={Wn}
M9 net19 net23 net45 net45 NMOS_CI2N L={Ln} W={Wn}
M10 net30 Vin_n net19 net19 NMOS_CI2N L={Ln} W={Wn}
M11 net45 net10 0 0 NMOS_CI2N L={Ln} W={Wn}
M12 net24 net23 net35 net35 NMOS_CI2N L={Ln} W={Wn}
M13 net37 net24 0 0 NMOS_CI2N L={Ln} W={Wn}
M14 net10 net23 net48 net48 NMOS_CI2N L={Ln} W={Wn}
M15 net47 net10 0 0 NMOS_CI2N L={Ln} W={Wn}
M16 net15 net23 net47 net47 NMOS_CI2N L={Ln} W={Wn}
M17 OUT net39 net42 net42 PMOS_CI2N L={Lp} W={Wp}
M18 net28 net39 net43 net43 PMOS_CI2N L={Lp} W={Wp}
M19 net42 net28 VDD VDD PMOS_CI2N L={Lp} W={Wp}
M20 net43 net28 VDD VDD PMOS_CI2N L={Lp} W={Wp}
M21 net22 net39 net32 net32 PMOS_CI2N L={Lp} W={Wp}
M22 net16 net15 net46 net46 PMOS_CI2N L={Lp} W={Wp}
M23 net24 net39 net30 net30 PMOS_CI2N L={Lp} W={Wp}
M24 net30 net40 VDD VDD PMOS_CI2N L={Lp} W={Wp}
M25 net32 net40 VDD VDD PMOS_CI2N L={Lp} W={Wp}
M26 net46 net16 VDD VDD PMOS_CI2N L={Lp} W={Wp}
M27 net23 VB VDD VDD PMOS_CI2N L={Lp} W={Wp}
R1 net23 net10 {Rval}
R2 net16 net15 {Rval}
* supply rails (added; not part of the CI2N netlist)
Vsup_VDD VDD 0 {VDD}
.op
.end
