* CI2N circuit from experiments/01-vllm-only/results/claude-sonnet-5.5/golden/089.json
* ckt_type: DISO-Amplifier
* generated by ci2n_to_spice.py
* renamed nets: VBIAS2$1 -> VBIAS2_1, VBIAS3$1 -> VBIAS3_1
* ---- placeholder values: CI2N netlists carry topology only; edit as needed ----
.param VDD=1.8 VSS=0
.param Rval=10k Cval=1p Ival=10u Vval=0.9
.param Wn=1u Ln=180n Wp=2u Lp=180n Aol=1e5
.model NMOS_CI2N NMOS (level=1 VTO=0.45 KP=200u LAMBDA=0.05)
.model PMOS_CI2N PMOS (level=1 VTO=-0.45 KP=80u LAMBDA=0.05)
.model NPN_CI2N NPN (Is=1e-16 Bf=100 Vaf=50)
.model PNP_CI2N PNP (Is=1e-16 Bf=50 Vaf=50)
.model D_CI2N D (Is=1e-14)

M1 net28 VBIAS3 VSS VSS NMOS_CI2N L={Ln} W={Wn}
M2 OUT VBIAS2 net28 net28 NMOS_CI2N L={Ln} W={Wn}
M3 net24 VBIAS2_1 net27 net27 NMOS_CI2N L={Ln} W={Wn}
M4 net27 VBIAS3_1 VSS VSS NMOS_CI2N L={Ln} W={Wn}
M5 net17 VBIAS1 VDD VDD PMOS_CI2N L={Lp} W={Wp}
M6 OUT net24 net30 net30 PMOS_CI2N L={Lp} W={Wp}
M7 net24 net24 net23 net23 PMOS_CI2N L={Lp} W={Wp}
M8 net30 net23 VDD VDD PMOS_CI2N L={Lp} W={Wp}
M9 net23 net23 VDD VDD PMOS_CI2N L={Lp} W={Wp}
M10 net28 INN net17 net17 PMOS_CI2N L={Lp} W={Wp}
M11 net27 INP net17 net17 PMOS_CI2N L={Lp} W={Wp}
C1 OUT 0 {Cval}
* supply rails (added; not part of the CI2N netlist)
Vsup_VSS VSS 0 {VSS}
Vsup_VDD VDD 0 {VDD}
.op
.end
