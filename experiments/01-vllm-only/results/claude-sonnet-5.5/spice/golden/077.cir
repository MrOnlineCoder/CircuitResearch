* CI2N circuit from experiments/01-vllm-only/results/claude-sonnet-5.5/golden/077.json
* ckt_type: DISO-Amplifier
* generated by ci2n_to_spice.py
* ---- placeholder values: CI2N netlists carry topology only; edit as needed ----
.param VDD=1.8 VSS=0
.param Rval=10k Cval=1p Ival=10u Vval=0.9
.param Wn=1u Ln=180n Wp=2u Lp=180n Aol=1e5
.model NMOS_CI2N NMOS (level=1 VTO=0.45 KP=200u LAMBDA=0.05)
.model PMOS_CI2N PMOS (level=1 VTO=-0.45 KP=80u LAMBDA=0.05)
.model NPN_CI2N NPN (Is=1e-16 Bf=100 Vaf=50)
.model PNP_CI2N PNP (Is=1e-16 Bf=50 Vaf=50)
.model D_CI2N D (Is=1e-14)

Q1 VEE net31 net22 PNP_CI2N
Q2 net32 net32 VCC PNP_CI2N
Q3 net17 net9 VCC PNP_CI2N
Q4 net10 net28 net29 PNP_CI2N
Q5 net9 net9 VCC PNP_CI2N
Q6 net28 net32 VCC PNP_CI2N
Q7 net1 net28 net30 PNP_CI2N
Q8 net17 net13 net31 NPN_CI2N
Q9 net17 net18 net38 NPN_CI2N
Q10 VCC net17 net18 NPN_CI2N
Q11 net31 net12 net14 NPN_CI2N
Q12 net7 net7 VEE NPN_CI2N
Q13 net28 net7 net23 NPN_CI2N
Q14 net10 net14 VEE NPN_CI2N
Q15 net32 vin net30 NPN_CI2N
Q16 net10 net2 net24 NPN_CI2N
Q17 net32 vip net29 NPN_CI2N
Q18 VCC net1 net2 NPN_CI2N
Q19 net1 net2 net25 NPN_CI2N
Q20 net31 net10 net12 NPN_CI2N
R1 net17 net13 {Rval}
R2 net31 net13 {Rval}
R3 net9 net7 {Rval}
R4 net18 net38 {Rval}
R5 net38 net22 {Rval}
R6 net14 VEE {Rval}
R7 net12 VEE {Rval}
R8 net25 VEE {Rval}
R9 net23 VEE {Rval}
R10 net2 VEE {Rval}
R11 net24 VEE {Rval}
C1 net17 net10 {Cval}
* supply rails (added; not part of the CI2N netlist)
Vsup_VEE VEE 0 {VSS}
Vsup_VCC VCC 0 {VDD}
.op
.end
