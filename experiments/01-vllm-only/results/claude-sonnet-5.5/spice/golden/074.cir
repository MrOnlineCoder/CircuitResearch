* CI2N circuit from experiments/01-vllm-only/results/claude-sonnet-5.5/golden/074.json
* ckt_type: DIDO-Amplifier
* generated by ci2n_to_spice.py
* renamed nets: vin- -> vin_n, vin+ -> vin_p
* ---- placeholder values: CI2N netlists carry topology only; edit as needed ----
.param VDD=1.8 VSS=0
.param Rval=10k Cval=1p Ival=10u Vval=0.9
.param Wn=1u Ln=180n Wp=2u Lp=180n Aol=1e5
.model NMOS_CI2N NMOS (level=1 VTO=0.45 KP=200u LAMBDA=0.05)
.model PMOS_CI2N PMOS (level=1 VTO=-0.45 KP=80u LAMBDA=0.05)
.model NPN_CI2N NPN (Is=1e-16 Bf=100 Vaf=50)
.model PNP_CI2N PNP (Is=1e-16 Bf=50 Vaf=50)
.model D_CI2N D (Is=1e-14)

C1 net23 net27 {Cval}
C2 net28 net6 {Cval}
R1 net27 net19 {Rval}
R2 net10 net28 {Rval}
M1 net33 net30 VSS VSS NMOS_CI2N L={Ln} W={Wn}
M2 net6 net10 VSS VSS NMOS_CI2N L={Ln} W={Wn}
M3 net32 net30 VSS VSS NMOS_CI2N L={Ln} W={Wn}
M4 net23 net19 VSS VSS NMOS_CI2N L={Ln} W={Wn}
M5 net19 net31 net32 net32 NMOS_CI2N L={Ln} W={Wn}
M6 net10 net31 net33 net33 NMOS_CI2N L={Ln} W={Wn}
M7 net23 net99 VDD VDD PMOS_CI2N L={Lp} W={Wp}
M8 net20 vin_n net16 net16 PMOS_CI2N L={Lp} W={Wp}
M9 net10 net29 net14 net14 PMOS_CI2N L={Lp} W={Wp}
M10 net19 net29 net20 net20 PMOS_CI2N L={Lp} W={Wp}
M11 net14 vin_p net16 net16 PMOS_CI2N L={Lp} W={Wp}
M12 net16 net8 VDD net99 PMOS_CI2N L={Lp} W={Wp}
M13 net6 net8 VDD VDD PMOS_CI2N L={Lp} W={Wp}
* supply rails (added; not part of the CI2N netlist)
Vsup_VSS VSS 0 {VSS}
Vsup_VDD VDD 0 {VDD}
.op
.end
