* CI2N circuit from experiments/01-vllm-only/results/claude-sonnet-5.5/golden/010.json
* ckt_type: DISO-Amplifier
* generated by ci2n_to_spice.py
* ---- placeholder values: CI2N netlists carry topology only; edit as needed ----
.param VDD=1.8 VSS=0
.param Rval=10k Cval=1p Ival=10u Vval=0.9
.param Wn=1u Ln=180n Wp=2u Lp=180n Aol=1e5
.model NMOS_CI2N NMOS (level=1 VTO=0.45 KP=200u LAMBDA=0.05)
.model PMOS_CI2N PMOS (level=1 VTO=-0.45 KP=80u LAMBDA=0.05)
.model NPN_CI2N NPN (Is=1e-16 Bf=100 Vaf=50)
.model PNP_CI2N PNP (Is=1e-16 Bf=50 Vaf=50)
.model D_CI2N D (Is=1e-14)

M1 net17 net4 VDD VDD PMOS_CI2N L={Lp} W={Wp}
M2 net15 net16 net14 net14 PMOS_CI2N L={Lp} W={Wp}
M3 net14 net3 VDD VDD PMOS_CI2N L={Lp} W={Wp}
M4 net13 net4 VDD VDD PMOS_CI2N L={Lp} W={Wp}
M5 net8 net9 net1 net1 PMOS_CI2N L={Lp} W={Wp}
M6 net6 net7 net1 net1 PMOS_CI2N L={Lp} W={Wp}
M7 net5 net5 VDD VDD PMOS_CI2N L={Lp} W={Wp}
M8 net4 net5 VDD VDD PMOS_CI2N L={Lp} W={Wp}
M9 net1 net3 VDD VDD PMOS_CI2N L={Lp} W={Wp}
M10 net17 net15 0 0 NMOS_CI2N L={Ln} W={Wn}
M11 net13 net12 0 0 NMOS_CI2N L={Ln} W={Wn}
M12 net13 net13 0 0 NMOS_CI2N L={Ln} W={Wn}
M13 net15 net13 0 0 NMOS_CI2N L={Ln} W={Wn}
M14 net8 net12 0 0 NMOS_CI2N L={Ln} W={Wn}
M15 net6 net12 0 0 NMOS_CI2N L={Ln} W={Wn}
M16 net5 net10 net8 net8 NMOS_CI2N L={Ln} W={Wn}
M17 net4 net10 net6 net6 NMOS_CI2N L={Ln} W={Wn}
R1 net15 net18 {Rval}
C1 net17 0 {Cval}
C2 net6 net17 {Cval}
C3 net18 0 {Cval}
* supply rails (added; not part of the CI2N netlist)
Vsup_VDD VDD 0 {VDD}
.op
.end
