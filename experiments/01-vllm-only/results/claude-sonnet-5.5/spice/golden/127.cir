* CI2N circuit from experiments/01-vllm-only/results/claude-sonnet-5.5/golden/127.json
* ckt_type: Comparator
* generated by ci2n_to_spice.py
* renamed nets: CLK$2 -> CLK_2, CLK$1 -> CLK_1
* ---- placeholder values: CI2N netlists carry topology only; edit as needed ----
.param VDD=1.8 VSS=0
.param Rval=10k Cval=1p Ival=10u Vval=0.9
.param Wn=1u Ln=180n Wp=2u Lp=180n Aol=1e5
.model NMOS_CI2N NMOS (level=1 VTO=0.45 KP=200u LAMBDA=0.05)
.model PMOS_CI2N PMOS (level=1 VTO=-0.45 KP=80u LAMBDA=0.05)
.model NPN_CI2N NPN (Is=1e-16 Bf=100 Vaf=50)
.model PNP_CI2N PNP (Is=1e-16 Bf=50 Vaf=50)
.model D_CI2N D (Is=1e-14)

V1 net6 0 {Vval}
V2 net5 0 {Vval}
M1 Vout1 CLK_2 VDD VDD PMOS_CI2N L={Lp} W={Wp}
M2 Vout2 Vout1 VDD VDD PMOS_CI2N L={Lp} W={Wp}
M3 Vout1 Vout2 VDD VDD PMOS_CI2N L={Lp} W={Wp}
M4 Vout2 CLK_1 VDD VDD PMOS_CI2N L={Lp} W={Wp}
M5 net4 net6 0 0 NMOS_CI2N L={Ln} W={Wn}
M6 net4 Vin2 0 0 NMOS_CI2N L={Ln} W={Wn}
M7 net3 net5 0 0 NMOS_CI2N L={Ln} W={Wn}
M8 net3 Vin1 0 0 NMOS_CI2N L={Ln} W={Wn}
M9 net2 Vout2 net4 net4 NMOS_CI2N L={Ln} W={Wn}
M10 net1 Vout1 net3 net3 NMOS_CI2N L={Ln} W={Wn}
M11 Vout1 CLK_2 net2 net2 NMOS_CI2N L={Ln} W={Wn}
M12 Vout2 CLK_1 net1 net1 NMOS_CI2N L={Ln} W={Wn}
* supply rails (added; not part of the CI2N netlist)
Vsup_VDD VDD 0 {VDD}
.op
.end
