* CI2N circuit from experiments/01-vllm-only/results/claude-sonnet-5.5/golden/029.json
* ckt_type: Bandgap
* generated by ci2n_to_spice.py
* renamed nets: vdd! -> vdd_
* ---- placeholder values: CI2N netlists carry topology only; edit as needed ----
.param VDD=1.8 VSS=0
.param Rval=10k Cval=1p Ival=10u Vval=0.9
.param Wn=1u Ln=180n Wp=2u Lp=180n Aol=1e5
.model NMOS_CI2N NMOS (level=1 VTO=0.45 KP=200u LAMBDA=0.05)
.model PMOS_CI2N PMOS (level=1 VTO=-0.45 KP=80u LAMBDA=0.05)
.model NPN_CI2N NPN (Is=1e-16 Bf=100 Vaf=50)
.model PNP_CI2N PNP (Is=1e-16 Bf=50 Vaf=50)
.model D_CI2N D (Is=1e-14)

M1 net9 net2 vdd_ vdd_ PMOS_CI2N L={Lp} W={Wp}
M2 Vref net4 net9 net9 PMOS_CI2N L={Lp} W={Wp}
M3 net2 net4 net8 net8 PMOS_CI2N L={Lp} W={Wp}
M4 net8 net2 vdd_ vdd_ PMOS_CI2N L={Lp} W={Wp}
M5 net7 net2 vdd_ vdd_ PMOS_CI2N L={Lp} W={Wp}
M6 net1 net4 net7 net7 PMOS_CI2N L={Lp} W={Wp}
M7 net18 net2 vdd_ vdd_ PMOS_CI2N L={Lp} W={Wp}
M8 net17 net4 net18 net18 PMOS_CI2N L={Lp} W={Wp}
M9 net4 net4 vdd_ vdd_ PMOS_CI2N L={Lp} W={Wp}
M10 net13 net4 net16 net16 PMOS_CI2N L={Lp} W={Wp}
M11 net16 net2 vdd_ vdd_ PMOS_CI2N L={Lp} W={Wp}
M12 net15 0 net14 net14 PMOS_CI2N L={Lp} W={Wp}
M13 net14 0 vdd_ vdd_ PMOS_CI2N L={Lp} W={Wp}
M14 net10 net1 net11 net11 NMOS_CI2N L={Ln} W={Wn}
M15 net2 net13 net10 net10 NMOS_CI2N L={Ln} W={Wn}
M16 net6 net1 net5 net5 NMOS_CI2N L={Ln} W={Wn}
M17 net1 net13 net6 net6 NMOS_CI2N L={Ln} W={Wn}
M18 net17 net17 0 0 NMOS_CI2N L={Ln} W={Wn}
M19 net4 net17 0 0 NMOS_CI2N L={Ln} W={Wn}
M20 net13 net13 net20 net20 NMOS_CI2N L={Ln} W={Wn}
M21 net15 net1 0 0 NMOS_CI2N L={Ln} W={Wn}
M22 net4 net15 0 0 NMOS_CI2N L={Ln} W={Wn}
M23 net2 net15 0 0 NMOS_CI2N L={Ln} W={Wn}
R1 net11 net12 {Rval}
R2 Vref net3 {Rval}
Q1 0 0 net20 PNP_CI2N
Q2 0 0 net5 PNP_CI2N
Q3 0 0 net12 PNP_CI2N
Q4 0 0 net3 PNP_CI2N
* supply rails (added; not part of the CI2N netlist)
Vsup_vdd_ vdd_ 0 {VDD}
.op
.end
