* CI2N circuit from experiments/01-vllm-only/results/claude-sonnet-5.5/golden/083.json
* ckt_type: DISO-Amplifier
* generated by ci2n_to_spice.py
* ---- placeholder values: CI2N netlists carry topology only; edit as needed ----
.param VDD=1.8 VSS=0
.param Rval=10k Cval=1p Ival=10u Vval=0.9
.param Wn=1u Ln=180n Wp=2u Lp=180n Aol=1e5
.model NMOS_CI2N NMOS (level=1 VTO=0.45 KP=200u LAMBDA=0.05)
.model PMOS_CI2N PMOS (level=1 VTO=-0.45 KP=80u LAMBDA=0.05)
.model NPN_CI2N NPN (Is=1e-16 Bf=100 Vaf=50)
.model PNP_CI2N PNP (Is=1e-16 Bf=50 Vaf=50)
.model D_CI2N D (Is=1e-14)

M1 net23 net23 0 0 NMOS_CI2N L={Ln} W={Wn}
M2 net7 net7 0 0 NMOS_CI2N L={Ln} W={Wn}
M3 net24 net24 net23 net23 NMOS_CI2N L={Ln} W={Wn}
M4 net19 net24 net26 net26 NMOS_CI2N L={Ln} W={Wn}
M5 vout net24 net25 net25 NMOS_CI2N L={Ln} W={Wn}
M6 net25 net7 0 0 NMOS_CI2N L={Ln} W={Wn}
M7 net26 net7 0 0 NMOS_CI2N L={Ln} W={Wn}
M8 net14 net9 VDD1 VDD1 PMOS_CI2N L={Lp} W={Wp}
M9 net26 vinp net14 net14 PMOS_CI2N L={Lp} W={Wp}
M10 net25 vinn net14 net14 PMOS_CI2N L={Lp} W={Wp}
M11 net24 net9 VDD2 VDD2 PMOS_CI2N L={Lp} W={Wp}
M12 net9 net9 VDD3 VDD3 PMOS_CI2N L={Lp} W={Wp}
M13 net20 net20 VDD4 VDD4 PMOS_CI2N L={Lp} W={Wp}
M14 net28 net20 VDD5 VDD5 PMOS_CI2N L={Lp} W={Wp}
M15 vout net19 net28 net28 PMOS_CI2N L={Lp} W={Wp}
M16 net19 net19 net20 net20 PMOS_CI2N L={Lp} W={Wp}
R1 net9 net7 {Rval}
C1 vout 0 {Cval}
* supply rails (added; not part of the CI2N netlist)
Vsup_VDD1 VDD1 0 {VDD}
Vsup_VDD2 VDD2 0 {VDD}
Vsup_VDD3 VDD3 0 {VDD}
Vsup_VDD4 VDD4 0 {VDD}
Vsup_VDD5 VDD5 0 {VDD}
.op
.end
