* CI2N circuit from experiments/01-vllm-only/results/claude-sonnet-5.5/golden/080.json
* ckt_type: DISO-Amplifier
* generated by ci2n_to_spice.py
* ---- placeholder values: CI2N netlists carry topology only; edit as needed ----
.param VDD=1.8 VSS=0
.param Rval=10k Cval=1p Ival=10u Vval=0.9
.param Wn=1u Ln=180n Wp=2u Lp=180n Aol=1e5
.model NMOS_CI2N NMOS (level=1 VTO=0.45 KP=200u LAMBDA=0.05)
.model PMOS_CI2N PMOS (level=1 VTO=-0.45 KP=80u LAMBDA=0.05)
.model NPN_CI2N NPN (Is=1e-16 Bf=100 Vaf=50)
.model PNP_CI2N PNP (Is=1e-16 Bf=50 Vaf=50)
.model D_CI2N D (Is=1e-14)

M1 vout net15 VDD VDD PMOS_CI2N L={Lp} W={Wp}
M2 net15 net18 VDD VDD PMOS_CI2N L={Lp} W={Wp}
M3 net18 net18 VDD VDD PMOS_CI2N L={Lp} W={Wp}
M4 net15 net10 VDD VDD PMOS_CI2N L={Lp} W={Wp}
M5 net10 net10 VDD VDD PMOS_CI2N L={Lp} W={Wp}
M6 VDD net15 net16 net16 NMOS_CI2N L={Ln} W={Wn}
M7 net15 vinp net11 net11 NMOS_CI2N L={Ln} W={Wn}
M8 net10 vref net11 net11 NMOS_CI2N L={Ln} W={Wn}
M9 net15 net18 net21 net21 NMOS_CI2N L={Ln} W={Wn}
M10 vout net16 0 0 NMOS_CI2N L={Ln} W={Wn}
M11 net21 net7 0 0 NMOS_CI2N L={Ln} W={Wn}
M12 net16 net7 0 0 NMOS_CI2N L={Ln} W={Wn}
M13 net18 net7 0 0 NMOS_CI2N L={Ln} W={Wn}
M14 net11 net7 0 0 NMOS_CI2N L={Ln} W={Wn}
M15 iref net7 0 0 NMOS_CI2N L={Ln} W={Wn}
C1 net21 vout {Cval}
C2 vout 0 {Cval}
* supply rails (added; not part of the CI2N netlist)
Vsup_VDD VDD 0 {VDD}
.op
.end
