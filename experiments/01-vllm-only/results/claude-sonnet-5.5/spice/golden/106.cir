* CI2N circuit from experiments/01-vllm-only/results/claude-sonnet-5.5/golden/106.json
* ckt_type: DIDO-Amplifier
* generated by ci2n_to_spice.py
* renamed nets: VOUT- -> VOUT_n, VOUT+ -> VOUT_p, VIN+ -> VIN_p, VIN- -> VIN_n
* ---- placeholder values: CI2N netlists carry topology only; edit as needed ----
.param VDD=1.8 VSS=0
.param Rval=10k Cval=1p Ival=10u Vval=0.9
.param Wn=1u Ln=180n Wp=2u Lp=180n Aol=1e5
.model NMOS_CI2N NMOS (level=1 VTO=0.45 KP=200u LAMBDA=0.05)
.model PMOS_CI2N PMOS (level=1 VTO=-0.45 KP=80u LAMBDA=0.05)
.model NPN_CI2N NPN (Is=1e-16 Bf=100 Vaf=50)
.model PNP_CI2N PNP (Is=1e-16 Bf=50 Vaf=50)
.model D_CI2N D (Is=1e-14)

M1 VOUT_n net4 0 0 NMOS_CI2N L={Ln} W={Wn}
M2 VOUT_p net3 0 0 NMOS_CI2N L={Ln} W={Wn}
M3 net3 VIN_p net1 net1 NMOS_CI2N L={Ln} W={Wn}
M4 net4 VIN_n net1 net1 NMOS_CI2N L={Ln} W={Wn}
M5 VOUT_p net5 VDD VDD PMOS_CI2N L={Lp} W={Wp}
M6 VOUT_n net5 VDD VDD PMOS_CI2N L={Lp} W={Wp}
M7 net4 net2 VDD VDD PMOS_CI2N L={Lp} W={Wp}
M8 net3 net2 VDD VDD PMOS_CI2N L={Lp} W={Wp}
R1 net5 VOUT_p {Rval}
R2 VOUT_n net5 {Rval}
R3 net2 net4 {Rval}
R4 net3 net2 {Rval}
I1 net1 0 {Ival}
* supply rails (added; not part of the CI2N netlist)
Vsup_VDD VDD 0 {VDD}
.op
.end
