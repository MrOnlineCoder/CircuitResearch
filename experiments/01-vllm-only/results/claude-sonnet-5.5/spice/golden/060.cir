* CI2N circuit from experiments/01-vllm-only/results/claude-sonnet-5.5/golden/060.json
* ckt_type: DISO-Amplifier
* generated by ci2n_to_spice.py
* renamed nets: \5V -> _5V, \-5V -> __n5V, V\+ -> V__p, V\- -> V__n
* ---- placeholder values: CI2N netlists carry topology only; edit as needed ----
.param VDD=1.8 VSS=0
.param Rval=10k Cval=1p Ival=10u Vval=0.9
.param Wn=1u Ln=180n Wp=2u Lp=180n Aol=1e5
.model NMOS_CI2N NMOS (level=1 VTO=0.45 KP=200u LAMBDA=0.05)
.model PMOS_CI2N PMOS (level=1 VTO=-0.45 KP=80u LAMBDA=0.05)
.model NPN_CI2N NPN (Is=1e-16 Bf=100 Vaf=50)
.model PNP_CI2N PNP (Is=1e-16 Bf=50 Vaf=50)
.model D_CI2N D (Is=1e-14)

Q1 Vout net4 _5V PNP_CI2N
Q2 0 net2 net1 PNP_CI2N
Q3 net4 net1 _5V PNP_CI2N
Q4 net2 net1 _5V PNP_CI2N
Q5 Vout net5 __n5V NPN_CI2N
Q6 net5 net5 __n5V NPN_CI2N
Q7 net3 net5 __n5V NPN_CI2N
Q8 net4 V__p net3 NPN_CI2N
Q9 net2 V__n net3 NPN_CI2N
R1 0 net5 {Rval}
.op
.end
