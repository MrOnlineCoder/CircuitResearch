* CI2N circuit from experiments/01-vllm-only/results/claude-sonnet-5.5/golden/035.json
* ckt_type: DIDO-Amplifier
* generated by ci2n_to_spice.py
* renamed nets: vdd! -> vdd_
* ---- placeholder values: CI2N netlists carry topology only; edit as needed ----
.param VDD=1.8 VSS=0
.param Rval=10k Cval=1p Ival=10u Vval=0.9
.param Wn=1u Ln=180n Wp=2u Lp=180n Aol=1e5
.model NMOS_CI2N NMOS (level=1 VTO=0.45 KP=200u LAMBDA=0.05)
.model PMOS_CI2N PMOS (level=1 VTO=-0.45 KP=80u LAMBDA=0.05)
.model NPN_CI2N NPN (Is=1e-16 Bf=100 Vaf=50)
.model PNP_CI2N PNP (Is=1e-16 Bf=50 Vaf=50)
.model D_CI2N D (Is=1e-14)

M1 v4 net1 vdd_ vdd_ PMOS_CI2N L={Lp} W={Wp}
M2 net1 net1 vdd_ vdd_ PMOS_CI2N L={Lp} W={Wp}
M3 net10 net10 vdd_ vdd_ PMOS_CI2N L={Lp} W={Wp}
M4 v3 net10 vdd_ vdd_ PMOS_CI2N L={Lp} W={Wp}
M5 net2 VBIAS 0 0 NMOS_CI2N L={Ln} W={Wn}
M6 v3 v1 net2 net2 NMOS_CI2N L={Ln} W={Wn}
M7 v4 v2 net2 net2 NMOS_CI2N L={Ln} W={Wn}
M8 net10 v2 net2 net2 NMOS_CI2N L={Ln} W={Wn}
M9 net1 v1 net2 net2 NMOS_CI2N L={Ln} W={Wn}
C1 v3 0 {Cval}
C2 v4 0 {Cval}
C3 net1 0 {Cval}
C4 net10 0 {Cval}
* supply rails (added; not part of the CI2N netlist)
Vsup_vdd_ vdd_ 0 {VDD}
.op
.end
