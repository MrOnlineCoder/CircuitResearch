* CI2N circuit from experiments/01-vllm-only/results/claude-sonnet-5.5/golden/040.json
* ckt_type: DISO-Amplifier
* generated by ci2n_to_spice.py
* renamed nets: Vin\+ -> Vin__p, Vin\- -> Vin__n
* ---- placeholder values: CI2N netlists carry topology only; edit as needed ----
.param VDD=1.8 VSS=0
.param Rval=10k Cval=1p Ival=10u Vval=0.9
.param Wn=1u Ln=180n Wp=2u Lp=180n Aol=1e5
.model NMOS_CI2N NMOS (level=1 VTO=0.45 KP=200u LAMBDA=0.05)
.model PMOS_CI2N PMOS (level=1 VTO=-0.45 KP=80u LAMBDA=0.05)
.model NPN_CI2N NPN (Is=1e-16 Bf=100 Vaf=50)
.model PNP_CI2N PNP (Is=1e-16 Bf=50 Vaf=50)
.model D_CI2N D (Is=1e-14)

M1 net12 Vin__p net10 net10 PMOS_CI2N L={Lp} W={Wp}
M2 net11 Vin__n net10 net10 PMOS_CI2N L={Lp} W={Wp}
M3 Vout net1 net9 net9 PMOS_CI2N L={Lp} W={Wp}
M4 net2 net1 net8 net8 PMOS_CI2N L={Lp} W={Wp}
M5 net10 net1 net7 net7 PMOS_CI2N L={Lp} W={Wp}
M6 net6 net1 net5 net5 PMOS_CI2N L={Lp} W={Wp}
M7 net9 net2 net4 net4 PMOS_CI2N L={Lp} W={Wp}
M8 net8 net2 net4 net4 PMOS_CI2N L={Lp} W={Wp}
M9 net7 net6 net4 net4 PMOS_CI2N L={Lp} W={Wp}
M10 net5 net6 net4 net4 PMOS_CI2N L={Lp} W={Wp}
M11 net3 VB net4 net4 PMOS_CI2N L={Lp} W={Wp}
M12 net15 net13 0 0 NMOS_CI2N L={Ln} W={Wn}
M13 net1 net3 net15 net15 NMOS_CI2N L={Ln} W={Wn}
M14 net13 net3 net14 net14 NMOS_CI2N L={Ln} W={Wn}
M15 net14 net13 0 0 NMOS_CI2N L={Ln} W={Wn}
M16 net2 Ncas net12 net12 NMOS_CI2N L={Ln} W={Wn}
M17 net12 net13 0 0 NMOS_CI2N L={Ln} W={Wn}
M18 net11 net13 0 0 NMOS_CI2N L={Ln} W={Wn}
M19 Vout Ncas net11 net11 NMOS_CI2N L={Ln} W={Wn}
R1 net6 net1 {Rval}
R2 net3 net13 {Rval}
.op
.end
