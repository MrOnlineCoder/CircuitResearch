* CI2N circuit from experiments/01-vllm-only/results/claude-sonnet-5.5/golden/016.json
* ckt_type: Bandgap
* generated by ci2n_to_spice.py
* renamed nets: vss! -> vss_
* ---- placeholder values: CI2N netlists carry topology only; edit as needed ----
.param VDD=1.8 VSS=0
.param Rval=10k Cval=1p Ival=10u Vval=0.9
.param Wn=1u Ln=180n Wp=2u Lp=180n Aol=1e5
.model NMOS_CI2N NMOS (level=1 VTO=0.45 KP=200u LAMBDA=0.05)
.model PMOS_CI2N PMOS (level=1 VTO=-0.45 KP=80u LAMBDA=0.05)
.model NPN_CI2N NPN (Is=1e-16 Bf=100 Vaf=50)
.model PNP_CI2N PNP (Is=1e-16 Bf=50 Vaf=50)
.model D_CI2N D (Is=1e-14)

.subckt DISO_AMP inp inn out
E1 out 0 inp inn {Aol}
.ends DISO_AMP

R1 vss_ net6 {Rval}
R2 net3 net1 {Rval}
R3 net1 net2 {Rval}
R4 net2 net4 {Rval}
R5 net1 vss_ {Rval}
Q1 vss_ vss_ net3 PNP_CI2N
Q2 vss_ vss_ net4 PNP_CI2N
M1 net3 net7 VDD VDD PMOS_CI2N L={Lp} W={Wp}
M2 net6 net7 VDD VDD PMOS_CI2N L={Lp} W={Wp}
M3 net2 net7 VDD VDD PMOS_CI2N L={Lp} W={Wp}
X1 net2 net3 net7 DISO_AMP
* supply rails (added; not part of the CI2N netlist)
Vsup_vss_ vss_ 0 {VSS}
Vsup_VDD VDD 0 {VDD}
.op
.end
