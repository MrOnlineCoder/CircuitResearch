* CI2N circuit from experiments/01-vllm-only/results/claude-sonnet-5.5/golden/070.json
* ckt_type: DISO-Amplifier
* generated by ci2n_to_spice.py
* ---- placeholder values: CI2N netlists carry topology only; edit as needed ----
.param VDD=1.8 VSS=0
.param Rval=10k Cval=1p Ival=10u Vval=0.9
.param Wn=1u Ln=180n Wp=2u Lp=180n Aol=1e5
.model NMOS_CI2N NMOS (level=1 VTO=0.45 KP=200u LAMBDA=0.05)
.model PMOS_CI2N PMOS (level=1 VTO=-0.45 KP=80u LAMBDA=0.05)
.model NPN_CI2N NPN (Is=1e-16 Bf=100 Vaf=50)
.model PNP_CI2N PNP (Is=1e-16 Bf=50 Vaf=50)
.model D_CI2N D (Is=1e-14)

M1 vout net5 VSS VSS NMOS_CI2N L={Ln} W={Wn}
M2 net1 net5 VSS VSS NMOS_CI2N L={Ln} W={Wn}
M3 net6 net5 VSS VSS NMOS_CI2N L={Ln} W={Wn}
M4 net3 net5 VSS VSS NMOS_CI2N L={Ln} W={Wn}
M5 net4 net8 net3 net3 NMOS_CI2N L={Ln} W={Wn}
M6 net2 net7 net3 net3 NMOS_CI2N L={Ln} W={Wn}
M7 vout net4 VDD VDD PMOS_CI2N L={Lp} W={Wp}
M8 net1 net1 VDD VDD PMOS_CI2N L={Lp} W={Wp}
M9 net4 net1 VDD VDD PMOS_CI2N L={Lp} W={Wp}
M10 net4 net2 VDD VDD PMOS_CI2N L={Lp} W={Wp}
M11 net2 net2 VDD VDD PMOS_CI2N L={Lp} W={Wp}
M12 net6 net6 net4 net4 PMOS_CI2N L={Lp} W={Wp}
C1 vout 0 {Cval}
C2 vout net6 {Cval}
* supply rails (added; not part of the CI2N netlist)
Vsup_VSS VSS 0 {VSS}
Vsup_VDD VDD 0 {VDD}
.op
.end
