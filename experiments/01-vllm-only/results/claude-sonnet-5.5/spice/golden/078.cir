* CI2N circuit from experiments/01-vllm-only/results/claude-sonnet-5.5/golden/078.json
* ckt_type: DISO-Amplifier
* generated by ci2n_to_spice.py
* ---- placeholder values: CI2N netlists carry topology only; edit as needed ----
.param VDD=1.8 VSS=0
.param Rval=10k Cval=1p Ival=10u Vval=0.9
.param Wn=1u Ln=180n Wp=2u Lp=180n Aol=1e5
.model NMOS_CI2N NMOS (level=1 VTO=0.45 KP=200u LAMBDA=0.05)
.model PMOS_CI2N PMOS (level=1 VTO=-0.45 KP=80u LAMBDA=0.05)
.model NPN_CI2N NPN (Is=1e-16 Bf=100 Vaf=50)
.model PNP_CI2N PNP (Is=1e-16 Bf=50 Vaf=50)
.model D_CI2N D (Is=1e-14)

M1 net13 vp net10 net10 NMOS_CI2N L={Ln} W={Wn}
M2 net11 vn net10 net10 NMOS_CI2N L={Ln} W={Wn}
M3 net16 net14 VSS VSS NMOS_CI2N L={Ln} W={Wn}
M4 net10 net14 VSS VSS NMOS_CI2N L={Ln} W={Wn}
M5 net5 net14 VSS VSS NMOS_CI2N L={Ln} W={Wn}
M6 net14 net14 VSS VSS NMOS_CI2N L={Ln} W={Wn}
M7 net5 net5 net6 net6 PMOS_CI2N L={Lp} W={Wp}
M8 net17 net5 net13 net13 PMOS_CI2N L={Lp} W={Wp}
M9 net16 net13 VDD VDD PMOS_CI2N L={Lp} W={Wp}
M10 net13 net11 VDD VDD PMOS_CI2N L={Lp} W={Wp}
M11 net11 net11 VDD VDD PMOS_CI2N L={Lp} W={Wp}
M12 net6 net6 VDD VDD PMOS_CI2N L={Lp} W={Wp}
I1 VDD net14 {Ival}
C1 net16 0 {Cval}
C2 net16 net17 {Cval}
* supply rails (added; not part of the CI2N netlist)
Vsup_VSS VSS 0 {VSS}
Vsup_VDD VDD 0 {VDD}
.op
.end
