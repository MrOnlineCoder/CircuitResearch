* CI2N circuit from experiments/03-hybrid/results/claude-sonnet-5.5-hybrid/preds/029.json
* generated by ci2n_to_spice.py
* ---- placeholder values: CI2N netlists carry topology only; edit as needed ----
.param VDD=1.8 VSS=0
.param Rval=10k Cval=1p Ival=10u Vval=0.9
.param Wn=1u Ln=180n Wp=2u Lp=180n Aol=1e5
.model NMOS_CI2N NMOS (level=1 VTO=0.45 KP=200u LAMBDA=0.05)
.model PMOS_CI2N PMOS (level=1 VTO=-0.45 KP=80u LAMBDA=0.05)
.model NPN_CI2N NPN (Is=1e-16 Bf=100 Vaf=50)
.model PNP_CI2N PNP (Is=1e-16 Bf=50 Vaf=50)
.model D_CI2N D (Is=1e-14)

M1 net1 G1 VDD VDD PMOS_CI2N L={Lp} W={Wp}
M2 net2 G1 VDD VDD PMOS_CI2N L={Lp} W={Wp}
M3 net3 G1 VDD VDD PMOS_CI2N L={Lp} W={Wp}
M4 net4 G1 VDD VDD PMOS_CI2N L={Lp} W={Wp}
M5 net5 0 VDD VDD PMOS_CI2N L={Lp} W={Wp}
M6 net6 G1 VDD VDD PMOS_CI2N L={Lp} W={Wp}
M7 nb G2 net3 net3 PMOS_CI2N L={Lp} W={Wp}
M8 H G2 net1 net1 PMOS_CI2N L={Lp} W={Wp}
M9 G2 G2 VDD VDD PMOS_CI2N L={Lp} W={Wp}
M10 net7 0 net5 net5 PMOS_CI2N L={Lp} W={Wp}
M11 G1 G2 net4 net4 PMOS_CI2N L={Lp} W={Wp}
M12 net8 G2 net2 net2 PMOS_CI2N L={Lp} W={Wp}
M13 L G2 net6 net6 PMOS_CI2N L={Lp} W={Wp}
M14 H L net9 net9 NMOS_CI2N L={Ln} W={Wn}
M15 G1 L net10 net10 NMOS_CI2N L={Ln} W={Wn}
R1 net8 net11 {Rval}
M16 net9 H net12 net12 NMOS_CI2N L={Ln} W={Wn}
M17 net10 H net13 net13 NMOS_CI2N L={Ln} W={Wn}
M18 G2 net7 0 0 NMOS_CI2N L={Ln} W={Wn}
M19 G1 net7 0 0 NMOS_CI2N L={Ln} W={Wn}
M20 L L net14 net14 NMOS_CI2N L={Ln} W={Wn}
R2 net13 net15 {Rval}
M21 net7 H 0 0 NMOS_CI2N L={Ln} W={Wn}
M22 nb nb 0 0 NMOS_CI2N L={Ln} W={Wn}
M23 G2 nb 0 0 NMOS_CI2N L={Ln} W={Wn}
Q1 0 0 net11 PNP_CI2N
Q2 0 0 net12 PNP_CI2N
Q3 0 0 net15 PNP_CI2N
Q4 0 0 net14 PNP_CI2N
* supply rails (added; not part of the CI2N netlist)
Vsup_VDD VDD 0 {VDD}
.op
.end
