* CI2N circuit from experiments/03-hybrid/results/claude-sonnet-5.5-hybrid/preds/105.json
* generated by ci2n_to_spice.py
* ---- placeholder values: CI2N netlists carry topology only; edit as needed ----
.param VDD=1.8 VSS=0
.param Rval=10k Cval=1p Ival=10u Vval=0.9
.param Wn=1u Ln=180n Wp=2u Lp=180n Aol=1e5
.model NMOS_CI2N NMOS (level=1 VTO=0.45 KP=200u LAMBDA=0.05)
.model PMOS_CI2N PMOS (level=1 VTO=-0.45 KP=80u LAMBDA=0.05)
.model NPN_CI2N NPN (Is=1e-16 Bf=100 Vaf=50)
.model PNP_CI2N PNP (Is=1e-16 Bf=50 Vaf=50)
.model D_CI2N D (Is=1e-14)

.subckt DISO_AMP inp inn out
E1 out 0 inp inn {Aol}
.ends DISO_AMP

M1 net1 net2 VDD VDD PMOS_CI2N L={Lp} W={Wp}
M2 net3 net2 VDD VDD PMOS_CI2N L={Lp} W={Wp}
M3 net12 net5 VDD VDD PMOS_CI2N L={Lp} W={Wp}
X1 net3 net1 net6 DISO_AMP
M4 net7 net6 net3 net3 PMOS_CI2N L={Lp} W={Wp}
M5 net9 net6 net1 net1 PMOS_CI2N L={Lp} W={Wp}
M6 net10 net11 net12 net12 PMOS_CI2N L={Lp} W={Wp}
M7 net13 net14 net12 net12 PMOS_CI2N L={Lp} W={Wp}
M8 net9 net16 net13 net13 NMOS_CI2N L={Ln} W={Wn}
M9 net7 net16 net10 net10 NMOS_CI2N L={Ln} W={Wn}
X2 net10 net13 net16 DISO_AMP
M10 net10 net18 0 0 NMOS_CI2N L={Ln} W={Wn}
M11 net13 net18 0 0 NMOS_CI2N L={Ln} W={Wn}
* supply rails (added; not part of the CI2N netlist)
Vsup_VDD VDD 0 {VDD}
.op
.end
