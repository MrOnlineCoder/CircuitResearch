* CI2N circuit from experiments/03-hybrid/results/claude-sonnet-5.5-hybrid/preds/095.json
* generated by ci2n_to_spice.py
* ---- placeholder values: CI2N netlists carry topology only; edit as needed ----
.param VDD=1.8 VSS=0
.param Rval=10k Cval=1p Ival=10u Vval=0.9
.param Wn=1u Ln=180n Wp=2u Lp=180n Aol=1e5
.model NMOS_CI2N NMOS (level=1 VTO=0.45 KP=200u LAMBDA=0.05)
.model PMOS_CI2N PMOS (level=1 VTO=-0.45 KP=80u LAMBDA=0.05)
.model NPN_CI2N NPN (Is=1e-16 Bf=100 Vaf=50)
.model PNP_CI2N PNP (Is=1e-16 Bf=50 Vaf=50)
.model D_CI2N D (Is=1e-14)

M1 net1 net2 net3 net3 PMOS_CI2N L={Lp} W={Wp}
M2 net5 net1 net3 net3 PMOS_CI2N L={Lp} W={Wp}
M3 net2 net2 net3 net3 PMOS_CI2N L={Lp} W={Wp}
I1 net3 net6 {Ival}
C1 net5 net1 {Cval}
C2 net2 net7 {Cval}
M4 net2 net8 new1 new1 NMOS_CI2N L={Ln} W={Wn}
M5 net1 net9 new1 new1 NMOS_CI2N L={Ln} W={Wn}
C3 net5 0 {Cval}
M6 net5 net6 net11 net11 NMOS_CI2N L={Ln} W={Wn}
M7 net6 net6 net11 net11 NMOS_CI2N L={Ln} W={Wn}
M8 new1 net6 net11 net11 NMOS_CI2N L={Ln} W={Wn}
.op
.end
