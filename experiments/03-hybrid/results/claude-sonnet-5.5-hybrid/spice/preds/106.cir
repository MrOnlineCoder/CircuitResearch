* CI2N circuit from experiments/03-hybrid/results/claude-sonnet-5.5-hybrid/preds/106.json
* generated by ci2n_to_spice.py
* ---- placeholder values: CI2N netlists carry topology only; edit as needed ----
.param VDD=1.8 VSS=0
.param Rval=10k Cval=1p Ival=10u Vval=0.9
.param Wn=1u Ln=180n Wp=2u Lp=180n Aol=1e5
.model NMOS_CI2N NMOS (level=1 VTO=0.45 KP=200u LAMBDA=0.05)
.model PMOS_CI2N PMOS (level=1 VTO=-0.45 KP=80u LAMBDA=0.05)
.model NPN_CI2N NPN (Is=1e-16 Bf=100 Vaf=50)
.model PNP_CI2N PNP (Is=1e-16 Bf=50 Vaf=50)
.model D_CI2N D (Is=1e-14)

M1 net1 net2 VDD VDD PMOS_CI2N L={Lp} W={Wp}
M2 nA net3 VDD VDD PMOS_CI2N L={Lp} W={Wp}
M3 net4 net2 VDD VDD PMOS_CI2N L={Lp} W={Wp}
M4 nB net3 VDD VDD PMOS_CI2N L={Lp} W={Wp}
R1 nA net3 {Rval}
R2 net1 net2 {Rval}
R3 net3 nB {Rval}
R4 net2 net4 {Rval}
M5 net1 nB 0 0 NMOS_CI2N L={Ln} W={Wn}
M6 nA net5 net6 net6 NMOS_CI2N L={Ln} W={Wn}
M7 nB vinn net6 net6 NMOS_CI2N L={Ln} W={Wn}
M8 net4 nA 0 0 NMOS_CI2N L={Ln} W={Wn}
I1 net6 0 {Ival}
* supply rails (added; not part of the CI2N netlist)
Vsup_VDD VDD 0 {VDD}
.op
.end
