* CI2N circuit from experiments/03-hybrid/results/claude-sonnet-5.5-hybrid/preds/007.json
* generated by ci2n_to_spice.py
* ---- placeholder values: CI2N netlists carry topology only; edit as needed ----
.param VDD=1.8 VSS=0
.param Rval=10k Cval=1p Ival=10u Vval=0.9
.param Wn=1u Ln=180n Wp=2u Lp=180n Aol=1e5
.model NMOS_CI2N NMOS (level=1 VTO=0.45 KP=200u LAMBDA=0.05)
.model PMOS_CI2N PMOS (level=1 VTO=-0.45 KP=80u LAMBDA=0.05)
.model NPN_CI2N NPN (Is=1e-16 Bf=100 Vaf=50)
.model PNP_CI2N PNP (Is=1e-16 Bf=50 Vaf=50)
.model D_CI2N D (Is=1e-14)

M1 net1 net2 VDD VDD PMOS_CI2N L={Lp} W={Wp}
M2 net3 net2 VDD VDD PMOS_CI2N L={Lp} W={Wp}
M3 net4 net2 VDD VDD PMOS_CI2N L={Lp} W={Wp}
M4 net5 net2 VDD VDD PMOS_CI2N L={Lp} W={Wp}
M5 net6 net2 VDD VDD PMOS_CI2N L={Lp} W={Wp}
M6 nb bias net4 net4 PMOS_CI2N L={Lp} W={Wp}
M7 na bias net5 net5 PMOS_CI2N L={Lp} W={Wp}
M8 net7 bias net1 net1 PMOS_CI2N L={Lp} W={Wp}
M9 tail bias net6 net6 PMOS_CI2N L={Lp} W={Wp}
M10 bias bias VDD VDD PMOS_CI2N L={Lp} W={Wp}
M11 net2 bias net3 net3 PMOS_CI2N L={Lp} W={Wp}
M12 opo nb tail tail PMOS_CI2N L={Lp} W={Wp}
M13 nc na tail tail PMOS_CI2N L={Lp} W={Wp}
R1 nb net8 {Rval}
R2 nb 0 {Rval}
R3 net7 0 {Rval}
R4 na 0 {Rval}
M14 bias opo 0 0 NMOS_CI2N L={Ln} W={Wn}
M15 net2 opo 0 0 NMOS_CI2N L={Ln} W={Wn}
M16 nc nc 0 0 NMOS_CI2N L={Ln} W={Wn}
M17 opo nc 0 0 NMOS_CI2N L={Ln} W={Wn}
Q1 0 0 net8 PNP_CI2N
Q2 0 0 na PNP_CI2N
V1 opo 0 {Vval}
* supply rails (added; not part of the CI2N netlist)
Vsup_VDD VDD 0 {VDD}
.op
.end
