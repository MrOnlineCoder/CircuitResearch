* CI2N circuit from experiments/03-hybrid/results/claude-sonnet-5.5-hybrid/preds/009.json
* generated by ci2n_to_spice.py
* ---- placeholder values: CI2N netlists carry topology only; edit as needed ----
.param VDD=1.8 VSS=0
.param Rval=10k Cval=1p Ival=10u Vval=0.9
.param Wn=1u Ln=180n Wp=2u Lp=180n Aol=1e5
.model NMOS_CI2N NMOS (level=1 VTO=0.45 KP=200u LAMBDA=0.05)
.model PMOS_CI2N PMOS (level=1 VTO=-0.45 KP=80u LAMBDA=0.05)
.model NPN_CI2N NPN (Is=1e-16 Bf=100 Vaf=50)
.model PNP_CI2N PNP (Is=1e-16 Bf=50 Vaf=50)
.model D_CI2N D (Is=1e-14)

.subckt DISO_AMP inp inn out
E1 out 0 inp inn {Aol}
.ends DISO_AMP

C1 gbus vdd {Cval}
M1 net1 gbus vdd vdd PMOS_CI2N L={Lp} W={Wp}
M2 net2 gbus vdd vdd PMOS_CI2N L={Lp} W={Wp}
M3 netA gbus vdd vdd PMOS_CI2N L={Lp} W={Wp}
M4 net3 gbus vdd vdd PMOS_CI2N L={Lp} W={Wp}
M5 net4 gbus vdd vdd PMOS_CI2N L={Lp} W={Wp}
M6 net5 gbus vdd vdd PMOS_CI2N L={Lp} W={Wp}
M7 netA net5 vdd vdd PMOS_CI2N L={Lp} W={Wp}
X1 net4 netA gbus DISO_AMP
M8 net5 gbus s1 s1 NMOS_CI2N L={Ln} W={Wn}
M9 net3 net3 net7 net7 NMOS_CI2N L={Ln} W={Wn}
M10 net7 net3 net8 net8 NMOS_CI2N L={Ln} W={Wn}
M11 net1 net1 net8 net8 NMOS_CI2N L={Ln} W={Wn}
M12 s1 s1 net9 net9 NMOS_CI2N L={Ln} W={Wn}
M13 net8 net1 net10 net10 NMOS_CI2N L={Ln} W={Wn}
M14 net9 net9 net11 net11 NMOS_CI2N L={Ln} W={Wn}
C2 net7 0 {Cval}
Q1 0 0 netA PNP_CI2N
R1 net4 0 {Rval}
R2 net10 0 {Rval}
M15 net11 net11 0 0 NMOS_CI2N L={Ln} W={Wn}
* supply rails (added; not part of the CI2N netlist)
Vsup_vdd vdd 0 {VDD}
.op
.end
