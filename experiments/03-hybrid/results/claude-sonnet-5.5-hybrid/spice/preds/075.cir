* CI2N circuit from experiments/03-hybrid/results/claude-sonnet-5.5-hybrid/preds/075.json
* generated by ci2n_to_spice.py
* ---- placeholder values: CI2N netlists carry topology only; edit as needed ----
.param VDD=1.8 VSS=0
.param Rval=10k Cval=1p Ival=10u Vval=0.9
.param Wn=1u Ln=180n Wp=2u Lp=180n Aol=1e5
.model NMOS_CI2N NMOS (level=1 VTO=0.45 KP=200u LAMBDA=0.05)
.model PMOS_CI2N PMOS (level=1 VTO=-0.45 KP=80u LAMBDA=0.05)
.model NPN_CI2N NPN (Is=1e-16 Bf=100 Vaf=50)
.model PNP_CI2N PNP (Is=1e-16 Bf=50 Vaf=50)
.model D_CI2N D (Is=1e-14)

M1 net1 net1 VDD VDD PMOS_CI2N L={Lp} W={Wp}
M2 net2 net1 VDD VDD PMOS_CI2N L={Lp} W={Wp}
M3 net3 net3 VDD VDD PMOS_CI2N L={Lp} W={Wp}
M4 net2 net2 VDD VDD PMOS_CI2N L={Lp} W={Wp}
M5 net4 net3 VDD VDD PMOS_CI2N L={Lp} W={Wp}
M6 net2 net2 VDD VDD PMOS_CI2N L={Lp} W={Wp}
M7 net5 net2 VDD VDD PMOS_CI2N L={Lp} W={Wp}
M8 net6 net7 net4 net4 PMOS_CI2N L={Lp} W={Wp}
M9 net7 net7 net3 net3 PMOS_CI2N L={Lp} W={Wp}
M10 net11 0 net2 net2 PMOS_CI2N L={Lp} W={Wp}
M11 net2 net8 net9 net9 NMOS_CI2N L={Ln} W={Wn}
M12 net1 net10 net9 net9 NMOS_CI2N L={Ln} W={Wn}
M13 new1 0 net2 net2 PMOS_CI2N L={Lp} W={Wp}
C1 net5 net11 {Cval}
C2 net5 0 {Cval}
M14 net7 net6 net12 net12 NMOS_CI2N L={Ln} W={Wn}
M15 net9 net6 net13 net13 NMOS_CI2N L={Ln} W={Wn}
M16 net6 net6 net13 net13 NMOS_CI2N L={Ln} W={Wn}
M17 new1 net6 net13 net13 NMOS_CI2N L={Ln} W={Wn}
M18 net11 net6 net13 net13 NMOS_CI2N L={Ln} W={Wn}
M19 net5 net6 net13 net13 NMOS_CI2N L={Ln} W={Wn}
R1 net12 net13 {Rval}
* supply rails (added; not part of the CI2N netlist)
Vsup_VDD VDD 0 {VDD}
.op
.end
