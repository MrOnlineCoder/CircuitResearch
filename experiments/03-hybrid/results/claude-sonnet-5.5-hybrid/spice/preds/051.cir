* CI2N circuit from experiments/03-hybrid/results/claude-sonnet-5.5-hybrid/preds/051.json
* generated by ci2n_to_spice.py
* ---- placeholder values: CI2N netlists carry topology only; edit as needed ----
.param VDD=1.8 VSS=0
.param Rval=10k Cval=1p Ival=10u Vval=0.9
.param Wn=1u Ln=180n Wp=2u Lp=180n Aol=1e5
.model NMOS_CI2N NMOS (level=1 VTO=0.45 KP=200u LAMBDA=0.05)
.model PMOS_CI2N PMOS (level=1 VTO=-0.45 KP=80u LAMBDA=0.05)
.model NPN_CI2N NPN (Is=1e-16 Bf=100 Vaf=50)
.model PNP_CI2N PNP (Is=1e-16 Bf=50 Vaf=50)
.model D_CI2N D (Is=1e-14)

M1 net1 net2 VDD VDD PMOS_CI2N L={Lp} W={Wp}
M2 net3 net4 VDD VDD PMOS_CI2N L={Lp} W={Wp}
M3 net5 net4 VDD VDD PMOS_CI2N L={Lp} W={Wp}
M4 net6 net2 VDD VDD PMOS_CI2N L={Lp} W={Wp}
M5 net8 net8 VDD VDD PMOS_CI2N L={Lp} W={Wp}
M6 net9 net9 VDD VDD PMOS_CI2N L={Lp} W={Wp}
R1 net8 net10 {Rval}
M7 net10 net11 net1 net1 PMOS_CI2N L={Lp} W={Wp}
R2 net9 net13 {Rval}
M8 net4 net13 net3 net3 PMOS_CI2N L={Lp} W={Wp}
M9 net11 net13 net5 net5 PMOS_CI2N L={Lp} W={Wp}
M10 newB net10 net5 net5 PMOS_CI2N L={Lp} W={Wp}
M11 net15 net11 VDD VDD PMOS_CI2N L={Lp} W={Wp}
I1 net13 0 {Ival}
I2 net10 0 {Ival}
M12 net16 net17 net6 net6 PMOS_CI2N L={Lp} W={Wp}
M13 net18 net19 net6 net6 PMOS_CI2N L={Lp} W={Wp}
M14 net15 newB 0 0 NMOS_CI2N L={Ln} W={Wn}
I3 VDD net20 {Ival}
M15 net4 net20 net16 net16 NMOS_CI2N L={Ln} W={Wn}
M16 net11 net22 net18 net18 NMOS_CI2N L={Ln} W={Wn}
M17 newB net20 net18 net18 NMOS_CI2N L={Ln} W={Wn}
R3 net20 net24 {Rval}
I4 VDD net22 {Ival}
M18 net24 net24 0 0 NMOS_CI2N L={Ln} W={Wn}
M19 net22 newB net25 net25 NMOS_CI2N L={Ln} W={Wn}
R4 net22 net26 {Rval}
M20 net26 net26 0 0 NMOS_CI2N L={Ln} W={Wn}
M21 net16 net27 0 0 NMOS_CI2N L={Ln} W={Wn}
M22 net25 net27 0 0 NMOS_CI2N L={Ln} W={Wn}
M23 net18 net27 0 0 NMOS_CI2N L={Ln} W={Wn}
* supply rails (added; not part of the CI2N netlist)
Vsup_VDD VDD 0 {VDD}
.op
.end
