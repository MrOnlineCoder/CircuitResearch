* CI2N circuit from experiments/03-hybrid/results/claude-sonnet-5.5-hybrid/preds/064.json
* generated by ci2n_to_spice.py
* ---- placeholder values: CI2N netlists carry topology only; edit as needed ----
.param VDD=1.8 VSS=0
.param Rval=10k Cval=1p Ival=10u Vval=0.9
.param Wn=1u Ln=180n Wp=2u Lp=180n Aol=1e5
.model NMOS_CI2N NMOS (level=1 VTO=0.45 KP=200u LAMBDA=0.05)
.model PMOS_CI2N PMOS (level=1 VTO=-0.45 KP=80u LAMBDA=0.05)
.model NPN_CI2N NPN (Is=1e-16 Bf=100 Vaf=50)
.model PNP_CI2N PNP (Is=1e-16 Bf=50 Vaf=50)
.model D_CI2N D (Is=1e-14)

M1 net2 net2 VDD VDD PMOS_CI2N L={Lp} W={Wp}
M2 net4 0 net2 net2 PMOS_CI2N L={Lp} W={Wp}
M3 net5 net5 net2 net2 PMOS_CI2N L={Lp} W={Wp}
M4 net6 net5 net2 net2 PMOS_CI2N L={Lp} W={Wp}
M5 net7 net2 net2 net2 PMOS_CI2N L={Lp} W={Wp}
M6 net8 net5 net2 net2 PMOS_CI2N L={Lp} W={Wp}
M7 net17 nc2 net4 net4 PMOS_CI2N L={Lp} W={Wp}
M8 net23 net11 net8 net8 PMOS_CI2N L={Lp} W={Wp}
M9 net5 net6 net13 net13 NMOS_CI2N L={Ln} W={Wn}
M10 net20 net15 net8 net8 PMOS_CI2N L={Lp} W={Wp}
C1 net16 net17 {Cval}
R1 net7 net16 {Rval}
M11 net6 net13 net18 net18 NMOS_CI2N L={Ln} W={Wn}
M12 net17 net7 net25 net25 NMOS_CI2N L={Ln} W={Wn}
M13 net18 net20 net18 net18 NMOS_CI2N L={Ln} W={Wn}
M14 net20 net20 net18 net18 NMOS_CI2N L={Ln} W={Wn}
M15 net7 net23 net18 net18 NMOS_CI2N L={Ln} W={Wn}
M16 net23 net23 net18 net18 NMOS_CI2N L={Ln} W={Wn}
M17 net25 0 net18 net18 NMOS_CI2N L={Ln} W={Wn}
R2 net13 net18 {Rval}
* supply rails (added; not part of the CI2N netlist)
Vsup_VDD VDD 0 {VDD}
.op
.end
