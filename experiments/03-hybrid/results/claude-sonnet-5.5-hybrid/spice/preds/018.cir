* CI2N circuit from experiments/03-hybrid/results/claude-sonnet-5.5-hybrid/preds/018.json
* generated by ci2n_to_spice.py
* ---- placeholder values: CI2N netlists carry topology only; edit as needed ----
.param VDD=1.8 VSS=0
.param Rval=10k Cval=1p Ival=10u Vval=0.9
.param Wn=1u Ln=180n Wp=2u Lp=180n Aol=1e5
.model NMOS_CI2N NMOS (level=1 VTO=0.45 KP=200u LAMBDA=0.05)
.model PMOS_CI2N PMOS (level=1 VTO=-0.45 KP=80u LAMBDA=0.05)
.model NPN_CI2N NPN (Is=1e-16 Bf=100 Vaf=50)
.model PNP_CI2N PNP (Is=1e-16 Bf=50 Vaf=50)
.model D_CI2N D (Is=1e-14)

R1 VDD v2 {Rval}
R2 VDD net2 {Rval}
M1 net3 net3 VDD VDD PMOS_CI2N L={Lp} W={Wp}
M2 v2 v2 net2 net2 PMOS_CI2N L={Lp} W={Wp}
M3 net4 net3 VDD VDD PMOS_CI2N L={Lp} W={Wp}
M4 net1 v2 VDD VDD PMOS_CI2N L={Lp} W={Wp}
M5 n6 net4 VDD VDD PMOS_CI2N L={Lp} W={Wp}
C1 net5 net1 {Cval}
R3 net4 net5 {Rval}
M6 net4 net6 net7 net7 NMOS_CI2N L={Ln} W={Wn}
M7 net3 net9 net7 net7 NMOS_CI2N L={Ln} W={Wn}
R4 net1 net9 {Rval}
C2 net1 net9 {Cval}
M8 v2 n6 net10 net10 NMOS_CI2N L={Ln} W={Wn}
M9 n6 n6 net10 net10 NMOS_CI2N L={Ln} W={Wn}
M10 net12 net12 net10 net10 NMOS_CI2N L={Ln} W={Wn}
M11 net7 net12 net10 net10 NMOS_CI2N L={Ln} W={Wn}
R5 net9 net10 {Rval}
* supply rails (added; not part of the CI2N netlist)
Vsup_VDD VDD 0 {VDD}
.op
.end
