* CI2N circuit from experiments/03-hybrid/results/claude-sonnet-5.5-hybrid/preds/097.json
* generated by ci2n_to_spice.py
* ---- placeholder values: CI2N netlists carry topology only; edit as needed ----
.param VDD=1.8 VSS=0
.param Rval=10k Cval=1p Ival=10u Vval=0.9
.param Wn=1u Ln=180n Wp=2u Lp=180n Aol=1e5
.model NMOS_CI2N NMOS (level=1 VTO=0.45 KP=200u LAMBDA=0.05)
.model PMOS_CI2N PMOS (level=1 VTO=-0.45 KP=80u LAMBDA=0.05)
.model NPN_CI2N NPN (Is=1e-16 Bf=100 Vaf=50)
.model PNP_CI2N PNP (Is=1e-16 Bf=50 Vaf=50)
.model D_CI2N D (Is=1e-14)

I1 VDD net1 {Ival}
M1 net2 net3 VDD VDD PMOS_CI2N L={Lp} W={Wp}
M2 net3 net4 VDD VDD PMOS_CI2N L={Lp} W={Wp}
M3 net4 net4 VDD VDD PMOS_CI2N L={Lp} W={Wp}
I2 VDD net5 {Ival}
M4 net1 net1 newA newA NMOS_CI2N L={Ln} W={Wn}
M5 net6 net2 VDD VDD PMOS_CI2N L={Lp} W={Wp}
M6 net7 net8 net2 net2 PMOS_CI2N L={Lp} W={Wp}
M7 VDD net1 newV2 newV2 NMOS_CI2N L={Ln} W={Wn}
R1 net3 net9 {Rval}
C1 net9 net7 {Cval}
R2 net6 net10 {Rval}
M8 net4 net11 tail tail NMOS_CI2N L={Ln} W={Wn}
M9 net3 net13 tail tail NMOS_CI2N L={Ln} W={Wn}
C2 net6 net10 {Cval}
M10 newV2 net14 net12 net12 NMOS_CI2N L={Ln} W={Wn}
M11 newA net7 net7 net14 NMOS_CI2N L={Ln} W={Wn}
M12 net6 newV2 net12 net12 NMOS_CI2N L={Ln} W={Wn}
M13 net7 net15 net16 net16 NMOS_CI2N L={Ln} W={Wn}
M14 net5 net5 net12 net12 NMOS_CI2N L={Ln} W={Wn}
M15 tail net5 net12 net12 NMOS_CI2N L={Ln} W={Wn}
M16 net16 net5 net12 net12 NMOS_CI2N L={Ln} W={Wn}
* supply rails (added; not part of the CI2N netlist)
Vsup_VDD VDD 0 {VDD}
.op
.end
