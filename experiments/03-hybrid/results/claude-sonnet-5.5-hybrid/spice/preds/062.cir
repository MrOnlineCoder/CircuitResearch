* CI2N circuit from experiments/03-hybrid/results/claude-sonnet-5.5-hybrid/preds/062.json
* generated by ci2n_to_spice.py
* ---- placeholder values: CI2N netlists carry topology only; edit as needed ----
.param VDD=1.8 VSS=0
.param Rval=10k Cval=1p Ival=10u Vval=0.9
.param Wn=1u Ln=180n Wp=2u Lp=180n Aol=1e5
.model NMOS_CI2N NMOS (level=1 VTO=0.45 KP=200u LAMBDA=0.05)
.model PMOS_CI2N PMOS (level=1 VTO=-0.45 KP=80u LAMBDA=0.05)
.model NPN_CI2N NPN (Is=1e-16 Bf=100 Vaf=50)
.model PNP_CI2N PNP (Is=1e-16 Bf=50 Vaf=50)
.model D_CI2N D (Is=1e-14)

M1 net1 net2 VDD VDD PMOS_CI2N L={Lp} W={Wp}
M2 net3 net2 VDD VDD PMOS_CI2N L={Lp} W={Wp}
M3 net4 net2 VDD VDD PMOS_CI2N L={Lp} W={Wp}
I1 VDD net5 {Ival}
M4 net2 net6 net3 net3 PMOS_CI2N L={Lp} W={Wp}
M5 net7 net6 net4 net4 PMOS_CI2N L={Lp} W={Wp}
R1 net2 net6 {Rval}
M6 net8 net9 VDD VDD PMOS_CI2N L={Lp} W={Wp}
M7 net10 net9 VDD VDD PMOS_CI2N L={Lp} W={Wp}
M8 net11 net1 VDD 0 PMOS_CI2N L={Lp} W={Wp}
M9 0 net7 net1 VDD PMOS_CI2N L={Lp} W={Wp}
M10 net9 net14 net8 net8 PMOS_CI2N L={Lp} W={Wp}
M11 net15 net14 net10 net10 PMOS_CI2N L={Lp} W={Wp}
C1 net7 0 {Cval}
R2 net9 net14 {Rval}
M12 VDD net7 net16 0 NMOS_CI2N L={Ln} W={Wn}
C2 net11 0 {Cval}
M13 net7 net15 net18 net18 NMOS_CI2N L={Ln} W={Wn}
M14 net6 net19 net20 net20 NMOS_CI2N L={Ln} W={Wn}
M15 net14 net21 net20 net20 NMOS_CI2N L={Ln} W={Wn}
R3 net15 new1 {Rval}
M16 0 net16 net11 VDD PMOS_CI2N L={Lp} W={Wp}
M17 new1 net15 net22 net22 NMOS_CI2N L={Ln} W={Wn}
M18 net5 net5 0 0 NMOS_CI2N L={Ln} W={Wn}
M19 net20 net5 0 0 NMOS_CI2N L={Ln} W={Wn}
M20 net16 net22 0 0 NMOS_CI2N L={Ln} W={Wn}
M21 net18 net22 0 0 NMOS_CI2N L={Ln} W={Wn}
M22 net22 net22 0 0 NMOS_CI2N L={Ln} W={Wn}
* supply rails (added; not part of the CI2N netlist)
Vsup_VDD VDD 0 {VDD}
.op
.end
