* CI2N circuit from experiments/03-hybrid/results/claude-sonnet-5.5-hybrid/preds/103.json
* generated by ci2n_to_spice.py
* ---- placeholder values: CI2N netlists carry topology only; edit as needed ----
.param VDD=1.8 VSS=0
.param Rval=10k Cval=1p Ival=10u Vval=0.9
.param Wn=1u Ln=180n Wp=2u Lp=180n Aol=1e5
.model NMOS_CI2N NMOS (level=1 VTO=0.45 KP=200u LAMBDA=0.05)
.model PMOS_CI2N PMOS (level=1 VTO=-0.45 KP=80u LAMBDA=0.05)
.model NPN_CI2N NPN (Is=1e-16 Bf=100 Vaf=50)
.model PNP_CI2N PNP (Is=1e-16 Bf=50 Vaf=50)
.model D_CI2N D (Is=1e-14)

M1 tail net1 net2 net2 PMOS_CI2N L={Lp} W={Wp}
M2 net3 net4 VDD VDD PMOS_CI2N L={Lp} W={Wp}
M3 net2 net4 VDD VDD PMOS_CI2N L={Lp} W={Wp}
M4 nD net6 tail tail PMOS_CI2N L={Lp} W={Wp}
M5 nA net6 tail tail PMOS_CI2N L={Lp} W={Wp}
M6 nC net7 tail tail PMOS_CI2N L={Lp} W={Wp}
M7 nB net7 tail tail PMOS_CI2N L={Lp} W={Wp}
M8 net8 vb6 net3 net3 PMOS_CI2N L={Lp} W={Wp}
M9 net4 vb6 net2 net2 PMOS_CI2N L={Lp} W={Wp}
M10 nD net9 s9 s9 NMOS_CI2N L={Ln} W={Wn}
M11 nC net9 s6 s6 NMOS_CI2N L={Ln} W={Wn}
M12 nC net9 s7 s7 NMOS_CI2N L={Ln} W={Wn}
M13 nD net9 s8 s8 NMOS_CI2N L={Ln} W={Wn}
M14 net4 net10 net11 net11 NMOS_CI2N L={Ln} W={Wn}
M15 net8 net10 net12 net12 NMOS_CI2N L={Ln} W={Wn}
M16 net12 net13 nB nB NMOS_CI2N L={Ln} W={Wn}
M17 net11 net13 nA nA NMOS_CI2N L={Ln} W={Wn}
M18 s6 nC 0 0 NMOS_CI2N L={Ln} W={Wn}
M19 nA nC 0 0 NMOS_CI2N L={Ln} W={Wn}
M20 s7 net14 0 0 NMOS_CI2N L={Ln} W={Wn}
M21 s9 nD 0 0 NMOS_CI2N L={Ln} W={Wn}
M22 s8 net14 0 0 NMOS_CI2N L={Ln} W={Wn}
M23 nB nD 0 0 NMOS_CI2N L={Ln} W={Wn}
* supply rails (added; not part of the CI2N netlist)
Vsup_VDD VDD 0 {VDD}
.op
.end
