* CI2N circuit from experiments/03-hybrid/results/claude-sonnet-5.5-hybrid/preds/121.json
* generated by ci2n_to_spice.py
* ---- placeholder values: CI2N netlists carry topology only; edit as needed ----
.param VDD=1.8 VSS=0
.param Rval=10k Cval=1p Ival=10u Vval=0.9
.param Wn=1u Ln=180n Wp=2u Lp=180n Aol=1e5
.model NMOS_CI2N NMOS (level=1 VTO=0.45 KP=200u LAMBDA=0.05)
.model PMOS_CI2N PMOS (level=1 VTO=-0.45 KP=80u LAMBDA=0.05)
.model NPN_CI2N NPN (Is=1e-16 Bf=100 Vaf=50)
.model PNP_CI2N PNP (Is=1e-16 Bf=50 Vaf=50)
.model D_CI2N D (Is=1e-14)

M1 net10 net2 VDD VDD PMOS_CI2N L={Lp} W={Wp}
M2 net3 net2 VDD VDD PMOS_CI2N L={Lp} W={Wp}
M3 net4 net2 VDD VDD PMOS_CI2N L={Lp} W={Wp}
M4 net5 net6 net4 net4 PMOS_CI2N L={Lp} W={Wp}
M5 net7 net6 net3 net3 PMOS_CI2N L={Lp} W={Wp}
M6 net9 net6 net10 net10 PMOS_CI2N L={Lp} W={Wp}
M7 net11 net12 net5 net5 PMOS_CI2N L={Lp} W={Wp}
M8 net13 net14 net5 net5 PMOS_CI2N L={Lp} W={Wp}
M9 net15 net16 net5 net5 PMOS_CI2N L={Lp} W={Wp}
M10 net7 net17 net15 net15 NMOS_CI2N L={Ln} W={Wn}
M11 net9 net17 net13 net13 NMOS_CI2N L={Ln} W={Wn}
R1 net11 0 {Rval}
M12 net15 net19 0 0 NMOS_CI2N L={Ln} W={Wn}
M13 net13 net19 0 0 NMOS_CI2N L={Ln} W={Wn}
* supply rails (added; not part of the CI2N netlist)
Vsup_VDD VDD 0 {VDD}
.op
.end
