* CI2N circuit from experiments/03-hybrid/results/claude-sonnet-5.5-hybrid/golden/052.json
* ckt_type: DISO-Amplifier
* generated by ci2n_to_spice.py
* ---- placeholder values: CI2N netlists carry topology only; edit as needed ----
.param VDD=1.8 VSS=0
.param Rval=10k Cval=1p Ival=10u Vval=0.9
.param Wn=1u Ln=180n Wp=2u Lp=180n Aol=1e5
.model NMOS_CI2N NMOS (level=1 VTO=0.45 KP=200u LAMBDA=0.05)
.model PMOS_CI2N PMOS (level=1 VTO=-0.45 KP=80u LAMBDA=0.05)
.model NPN_CI2N NPN (Is=1e-16 Bf=100 Vaf=50)
.model PNP_CI2N PNP (Is=1e-16 Bf=50 Vaf=50)
.model D_CI2N D (Is=1e-14)

M1 OUT net1 VDD VDD PMOS_CI2N L={Lp} W={Wp}
M2 net3 net6 net5 net5 PMOS_CI2N L={Lp} W={Wp}
M3 net9 net6 net4 net4 PMOS_CI2N L={Lp} W={Wp}
M4 net5 VINN net8 net8 PMOS_CI2N L={Lp} W={Wp}
M5 net4 VINM net8 net8 PMOS_CI2N L={Lp} W={Wp}
M6 net6 net6 net1 net1 PMOS_CI2N L={Lp} W={Wp}
M7 net8 net1 VDD VDD PMOS_CI2N L={Lp} W={Wp}
M8 net1 net1 VDD VDD PMOS_CI2N L={Lp} W={Wp}
M9 OUT net3 VSS VSS NMOS_CI2N L={Ln} W={Wn}
M10 net3 net9 net10 VSS1 NMOS_CI2N L={Ln} W={Wn}
M11 net9 net9 net11 VSS2 NMOS_CI2N L={Ln} W={Wn}
M12 net6 IBIAS VSS VSS NMOS_CI2N L={Ln} W={Wn}
M13 IBIAS IBIAS VSS VSS NMOS_CI2N L={Ln} W={Wn}
R1 net2 net3 {Rval}
R2 net10 VSS {Rval}
R3 net11 VSS {Rval}
C1 net2 OUT {Cval}
* supply rails (added; not part of the CI2N netlist)
Vsup_VDD VDD 0 {VDD}
Vsup_VSS VSS 0 {VSS}
Vsup_VSS1 VSS1 0 {VSS}
Vsup_VSS2 VSS2 0 {VSS}
.op
.end
