* CI2N circuit from experiments/03-hybrid/results/claude-sonnet-5.5-hybrid/golden/094.json
* ckt_type: DISO-Amplifier
* generated by ci2n_to_spice.py
* ---- placeholder values: CI2N netlists carry topology only; edit as needed ----
.param VDD=1.8 VSS=0
.param Rval=10k Cval=1p Ival=10u Vval=0.9
.param Wn=1u Ln=180n Wp=2u Lp=180n Aol=1e5
.model NMOS_CI2N NMOS (level=1 VTO=0.45 KP=200u LAMBDA=0.05)
.model PMOS_CI2N PMOS (level=1 VTO=-0.45 KP=80u LAMBDA=0.05)
.model NPN_CI2N NPN (Is=1e-16 Bf=100 Vaf=50)
.model PNP_CI2N PNP (Is=1e-16 Bf=50 Vaf=50)
.model D_CI2N D (Is=1e-14)

C1 net25 OUT {Cval}
M1 OUT net18 0 0 NMOS_CI2N L={Ln} W={Wn}
M2 net18 net15 0 0 NMOS_CI2N L={Ln} W={Wn}
M3 net15 net15 0 0 NMOS_CI2N L={Ln} W={Wn}
M4 net13 net7 0 0 NMOS_CI2N L={Ln} W={Wn}
M5 net9 net13 0 0 NMOS_CI2N L={Ln} W={Wn}
M6 net9 net7 0 0 NMOS_CI2N L={Ln} W={Wn}
M7 net7 net7 0 0 NMOS_CI2N L={Ln} W={Wn}
M8 OUT net9 VDD VDD PMOS_CI2N L={Lp} W={Wp}
M9 net16 net9 VDD VDD PMOS_CI2N L={Lp} W={Wp}
M10 net18 VIP net16 net16 PMOS_CI2N L={Lp} W={Wp}
M11 net15 VIN net16 net16 PMOS_CI2N L={Lp} W={Wp}
M12 net14 net14 VDD VDD PMOS_CI2N L={Lp} W={Wp}
M13 net7 net9 net26 net26 PMOS_CI2N L={Lp} W={Wp}
M14 net9 net9 VDD VDD PMOS_CI2N L={Lp} W={Wp}
R1 net18 net25 {Rval}
R2 net14 net13 {Rval}
R3 VDD net26 {Rval}
* supply rails (added; not part of the CI2N netlist)
Vsup_VDD VDD 0 {VDD}
.op
.end
