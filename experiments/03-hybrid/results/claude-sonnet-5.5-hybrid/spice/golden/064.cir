* CI2N circuit from experiments/03-hybrid/results/claude-sonnet-5.5-hybrid/golden/064.json
* ckt_type: DISO-Amplifier
* generated by ci2n_to_spice.py
* ---- placeholder values: CI2N netlists carry topology only; edit as needed ----
.param VDD=1.8 VSS=0
.param Rval=10k Cval=1p Ival=10u Vval=0.9
.param Wn=1u Ln=180n Wp=2u Lp=180n Aol=1e5
.model NMOS_CI2N NMOS (level=1 VTO=0.45 KP=200u LAMBDA=0.05)
.model PMOS_CI2N PMOS (level=1 VTO=-0.45 KP=80u LAMBDA=0.05)
.model NPN_CI2N NPN (Is=1e-16 Bf=100 Vaf=50)
.model PNP_CI2N PNP (Is=1e-16 Bf=50 Vaf=50)
.model D_CI2N D (Is=1e-14)

M1 net22 net16 net19 net19 NMOS_CI2N L={Ln} W={Wn}
M2 net19 0 VSS VSS NMOS_CI2N L={Ln} W={Wn}
M3 net16 net13 VSS VSS NMOS_CI2N L={Ln} W={Wn}
M4 net13 net13 VSS VSS NMOS_CI2N L={Ln} W={Wn}
M5 net9 net9 VSS VSS NMOS_CI2N L={Ln} W={Wn}
M6 net7 net9 VSS VSS NMOS_CI2N L={Ln} W={Wn}
M7 net2 net1 net4 net4 NMOS_CI2N L={Ln} W={Wn}
M8 net1 net4 VSS VSS NMOS_CI2N L={Ln} W={Wn}
M9 net22 net16 net39 net39 PMOS_CI2N L={Lp} W={Wp}
M10 net39 0 VDD VDD PMOS_CI2N L={Lp} W={Wp}
M11 net16 net7 VDD VDD PMOS_CI2N L={Lp} W={Wp}
M12 net13 net35 net27 net27 PMOS_CI2N L={Lp} W={Wp}
M13 net9 net32 net27 net27 PMOS_CI2N L={Lp} W={Wp}
M14 net27 net2 VDD VDD PMOS_CI2N L={Lp} W={Wp}
M15 net7 net7 VDD VDD PMOS_CI2N L={Lp} W={Wp}
M16 net2 net2 VDD VDD PMOS_CI2N L={Lp} W={Wp}
M17 net1 net2 VDD VDD PMOS_CI2N L={Lp} W={Wp}
R1 net46 net16 {Rval}
R2 net4 VSS {Rval}
C1 net22 net46 {Cval}
* supply rails (added; not part of the CI2N netlist)
Vsup_VSS VSS 0 {VSS}
Vsup_VDD VDD 0 {VDD}
.op
.end
