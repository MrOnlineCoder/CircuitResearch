* CI2N circuit from experiments/03-hybrid/results/claude-sonnet-5.5-hybrid/golden/086.json
* ckt_type: DISO-Amplifier
* generated by ci2n_to_spice.py
* renamed nets: v+ -> v_p, v- -> v_n
* ---- placeholder values: CI2N netlists carry topology only; edit as needed ----
.param VDD=1.8 VSS=0
.param Rval=10k Cval=1p Ival=10u Vval=0.9
.param Wn=1u Ln=180n Wp=2u Lp=180n Aol=1e5
.model NMOS_CI2N NMOS (level=1 VTO=0.45 KP=200u LAMBDA=0.05)
.model PMOS_CI2N PMOS (level=1 VTO=-0.45 KP=80u LAMBDA=0.05)
.model NPN_CI2N NPN (Is=1e-16 Bf=100 Vaf=50)
.model PNP_CI2N PNP (Is=1e-16 Bf=50 Vaf=50)
.model D_CI2N D (Is=1e-14)

M1 net13 net3 0 0 NMOS_CI2N L={Ln} W={Wn}
M2 net3 net3 0 0 NMOS_CI2N L={Ln} W={Wn}
M3 net4 net3 0 0 NMOS_CI2N L={Ln} W={Wn}
M4 net11 v_p net4 net4 NMOS_CI2N L={Ln} W={Wn}
M5 net7 v_n net4 net4 NMOS_CI2N L={Ln} W={Wn}
M6 net3 net3 VDD VDD PMOS_CI2N L={Lp} W={Wp}
M7 net13 net11 VDD VDD PMOS_CI2N L={Lp} W={Wp}
M8 net11 net7 VDD VDD PMOS_CI2N L={Lp} W={Wp}
M9 net7 net7 VDD VDD PMOS_CI2N L={Lp} W={Wp}
C1 net11 net13 {Cval}
* supply rails (added; not part of the CI2N netlist)
Vsup_VDD VDD 0 {VDD}
.op
.end
