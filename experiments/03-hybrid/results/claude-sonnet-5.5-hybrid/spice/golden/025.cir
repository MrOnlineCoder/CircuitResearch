* CI2N circuit from experiments/03-hybrid/results/claude-sonnet-5.5-hybrid/golden/025.json
* ckt_type: Bandgap
* generated by ci2n_to_spice.py
* renamed nets: vdd! -> vdd_
* ---- placeholder values: CI2N netlists carry topology only; edit as needed ----
.param VDD=1.8 VSS=0
.param Rval=10k Cval=1p Ival=10u Vval=0.9
.param Wn=1u Ln=180n Wp=2u Lp=180n Aol=1e5
.model NMOS_CI2N NMOS (level=1 VTO=0.45 KP=200u LAMBDA=0.05)
.model PMOS_CI2N PMOS (level=1 VTO=-0.45 KP=80u LAMBDA=0.05)
.model NPN_CI2N NPN (Is=1e-16 Bf=100 Vaf=50)
.model PNP_CI2N PNP (Is=1e-16 Bf=50 Vaf=50)
.model D_CI2N D (Is=1e-14)

.subckt DISO_AMP inp inn out
E1 out 0 inp inn {Aol}
.ends DISO_AMP

M1 net1 net1 vdd_ vdd_ PMOS_CI2N L={Lp} W={Wp}
M2 net2 net8 vdd_ vdd_ PMOS_CI2N L={Lp} W={Wp}
M3 net9 net8 vdd_ vdd_ PMOS_CI2N L={Lp} W={Wp}
M4 net7 net8 vdd_ vdd_ PMOS_CI2N L={Lp} W={Wp}
M5 net8 net1 0 0 NMOS_CI2N L={Ln} W={Wn}
M6 net1 net2 0 0 NMOS_CI2N L={Ln} W={Wn}
R1 net2 net3 {Rval}
R2 net6 net5 {Rval}
R3 net9 net4 {Rval}
R4 net7 net6 {Rval}
Q1 0 0 net3 PNP_CI2N
Q2 0 0 net4 PNP_CI2N
Q3 0 0 net5 PNP_CI2N
C1 vdd_ net8 {Cval}
X1 net6 net4 net8 DISO_AMP
* supply rails (added; not part of the CI2N netlist)
Vsup_vdd_ vdd_ 0 {VDD}
.op
.end
