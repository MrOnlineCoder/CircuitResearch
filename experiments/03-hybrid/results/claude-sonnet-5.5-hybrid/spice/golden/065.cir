* CI2N circuit from experiments/03-hybrid/results/claude-sonnet-5.5-hybrid/golden/065.json
* ckt_type: LDO
* generated by ci2n_to_spice.py
* ---- placeholder values: CI2N netlists carry topology only; edit as needed ----
.param VDD=1.8 VSS=0
.param Rval=10k Cval=1p Ival=10u Vval=0.9
.param Wn=1u Ln=180n Wp=2u Lp=180n Aol=1e5
.model NMOS_CI2N NMOS (level=1 VTO=0.45 KP=200u LAMBDA=0.05)
.model PMOS_CI2N PMOS (level=1 VTO=-0.45 KP=80u LAMBDA=0.05)
.model NPN_CI2N NPN (Is=1e-16 Bf=100 Vaf=50)
.model PNP_CI2N PNP (Is=1e-16 Bf=50 Vaf=50)
.model D_CI2N D (Is=1e-14)

M1 net15 net4 net14 net14 PMOS_CI2N L={Lp} W={Wp}
M2 net10 net14 net1 net1 PMOS_CI2N L={Lp} W={Wp}
M3 net14 net14 net1 net1 PMOS_CI2N L={Lp} W={Wp}
M4 net12 net14 net1 net1 PMOS_CI2N L={Lp} W={Wp}
M5 net14 net9 net1 net1 PMOS_CI2N L={Lp} W={Wp}
M6 net12 net9 net1 net1 PMOS_CI2N L={Lp} W={Wp}
M7 net4 net3 net7 net7 PMOS_CI2N L={Lp} W={Wp}
M8 net7 net7 net1 net1 PMOS_CI2N L={Lp} W={Wp}
M9 net3 net3 net6 net6 PMOS_CI2N L={Lp} W={Wp}
M10 net6 net7 net1 net1 PMOS_CI2N L={Lp} W={Wp}
M11 net8 net11 net2 net2 PMOS_CI2N L={Lp} W={Wp}
M12 net5 net13 net2 net2 PMOS_CI2N L={Lp} W={Wp}
M13 net2 net9 net1 net1 PMOS_CI2N L={Lp} W={Wp}
M14 net5 net18 0 0 NMOS_CI2N L={Ln} W={Wn}
M15 net8 net18 0 0 NMOS_CI2N L={Ln} W={Wn}
M16 net4 net17 net5 net5 NMOS_CI2N L={Ln} W={Wn}
M17 net3 net17 net8 net8 NMOS_CI2N L={Ln} W={Wn}
M18 net15 net12 0 0 NMOS_CI2N L={Ln} W={Wn}
M19 net12 net12 0 0 NMOS_CI2N L={Ln} W={Wn}
M20 net14 net15 0 0 NMOS_CI2N L={Ln} W={Wn}
R1 net10 0 {Rval}
R2 net11 0 {Rval}
R3 net10 net11 {Rval}
C1 net10 0 {Cval}
C2 net5 net10 {Cval}
.op
.end
