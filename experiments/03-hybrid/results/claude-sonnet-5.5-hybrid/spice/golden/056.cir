* CI2N circuit from experiments/03-hybrid/results/claude-sonnet-5.5-hybrid/golden/056.json
* ckt_type: DIDO-Amplifier
* generated by ci2n_to_spice.py
* ---- placeholder values: CI2N netlists carry topology only; edit as needed ----
.param VDD=1.8 VSS=0
.param Rval=10k Cval=1p Ival=10u Vval=0.9
.param Wn=1u Ln=180n Wp=2u Lp=180n Aol=1e5
.model NMOS_CI2N NMOS (level=1 VTO=0.45 KP=200u LAMBDA=0.05)
.model PMOS_CI2N PMOS (level=1 VTO=-0.45 KP=80u LAMBDA=0.05)
.model NPN_CI2N NPN (Is=1e-16 Bf=100 Vaf=50)
.model PNP_CI2N PNP (Is=1e-16 Bf=50 Vaf=50)
.model D_CI2N D (Is=1e-14)

M1 vo1 net2 net1 net1 PMOS_CI2N L={Lp} W={Wp}
M2 vo2 net4 net1 net1 PMOS_CI2N L={Lp} W={Wp}
M3 net4 net3 VDD VDD PMOS_CI2N L={Lp} W={Wp}
M4 net2 net3 VDD VDD PMOS_CI2N L={Lp} W={Wp}
M5 net1 vo2 VDD VDD PMOS_CI2N L={Lp} W={Wp}
M6 net1 vo1 VDD VDD PMOS_CI2N L={Lp} W={Wp}
R1 net4 net6 {Rval}
R2 net2 net5 {Rval}
C1 vo1 net5 {Cval}
C2 vo2 net6 {Cval}
M7 vo1 net8 VSS VSS NMOS_CI2N L={Ln} W={Wn}
M8 vo2 net8 VSS VSS NMOS_CI2N L={Ln} W={Wn}
M9 net7 net8 VSS VSS NMOS_CI2N L={Ln} W={Wn}
M10 net2 vi1 net7 net7 NMOS_CI2N L={Ln} W={Wn}
M11 net4 vi2 net7 net7 NMOS_CI2N L={Ln} W={Wn}
* supply rails (added; not part of the CI2N netlist)
Vsup_VDD VDD 0 {VDD}
Vsup_VSS VSS 0 {VSS}
.op
.end
