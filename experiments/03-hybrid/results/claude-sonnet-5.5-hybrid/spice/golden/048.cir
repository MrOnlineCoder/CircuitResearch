* CI2N circuit from experiments/03-hybrid/results/claude-sonnet-5.5-hybrid/golden/048.json
* ckt_type: DISO-Amplifier
* generated by ci2n_to_spice.py
* renamed nets: -3V -> _n3V
* ---- placeholder values: CI2N netlists carry topology only; edit as needed ----
.param VDD=1.8 VSS=0
.param Rval=10k Cval=1p Ival=10u Vval=0.9
.param Wn=1u Ln=180n Wp=2u Lp=180n Aol=1e5
.model NMOS_CI2N NMOS (level=1 VTO=0.45 KP=200u LAMBDA=0.05)
.model PMOS_CI2N PMOS (level=1 VTO=-0.45 KP=80u LAMBDA=0.05)
.model NPN_CI2N NPN (Is=1e-16 Bf=100 Vaf=50)
.model PNP_CI2N PNP (Is=1e-16 Bf=50 Vaf=50)
.model D_CI2N D (Is=1e-14)

M1 VOUT net1 net4 net4 PMOS_CI2N L={Lp} W={Wp}
M2 net5 net1 net3 net3 PMOS_CI2N L={Lp} W={Wp}
M3 net1 net1 3V 3V PMOS_CI2N L={Lp} W={Wp}
M4 net4 net2 3V 3V PMOS_CI2N L={Lp} W={Wp}
M5 net3 net2 3V 3V PMOS_CI2N L={Lp} W={Wp}
M6 net2 net2 3V 3V PMOS_CI2N L={Lp} W={Wp}
M7 net3 V1 net10 net10 NMOS_CI2N L={Ln} W={Wn}
M8 net4 V2 net10 net10 NMOS_CI2N L={Ln} W={Wn}
M9 net11 net11 _n3V _n3V NMOS_CI2N L={Ln} W={Wn}
M10 net1 net11 _n3V _n3V NMOS_CI2N L={Ln} W={Wn}
M11 net10 net11 _n3V _n3V NMOS_CI2N L={Ln} W={Wn}
M12 net8 net8 _n3V _n3V NMOS_CI2N L={Ln} W={Wn}
M13 net7 net8 _n3V _n3V NMOS_CI2N L={Ln} W={Wn}
M14 net5 net5 net8 net8 NMOS_CI2N L={Ln} W={Wn}
M15 VOUT net5 net7 net7 NMOS_CI2N L={Ln} W={Wn}
I1 net2 net11 {Ival}
C1 VOUT 0 {Cval}
.op
.end
