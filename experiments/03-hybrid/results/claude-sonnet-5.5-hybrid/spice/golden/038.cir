* CI2N circuit from experiments/03-hybrid/results/claude-sonnet-5.5-hybrid/golden/038.json
* ckt_type: Comparator
* generated by ci2n_to_spice.py
* renamed nets: vdd! -> vdd_, vout\+ -> vout__p, vout\- -> vout__n
* ---- placeholder values: CI2N netlists carry topology only; edit as needed ----
.param VDD=1.8 VSS=0
.param Rval=10k Cval=1p Ival=10u Vval=0.9
.param Wn=1u Ln=180n Wp=2u Lp=180n Aol=1e5
.model NMOS_CI2N NMOS (level=1 VTO=0.45 KP=200u LAMBDA=0.05)
.model PMOS_CI2N PMOS (level=1 VTO=-0.45 KP=80u LAMBDA=0.05)
.model NPN_CI2N NPN (Is=1e-16 Bf=100 Vaf=50)
.model PNP_CI2N PNP (Is=1e-16 Bf=50 Vaf=50)
.model D_CI2N D (Is=1e-14)

M1 net2 latch2 vdd_ vdd_ PMOS_CI2N L={Lp} W={Wp}
M2 vout__p latch2 vdd_ vdd_ PMOS_CI2N L={Lp} W={Wp}
M3 vout__p vout__n vdd_ vdd_ PMOS_CI2N L={Lp} W={Wp}
M4 vout__n vout__p vdd_ vdd_ PMOS_CI2N L={Lp} W={Wp}
M5 vout__n latch1 vdd_ vdd_ PMOS_CI2N L={Lp} W={Wp}
M6 net1 latch1 vdd_ vdd_ PMOS_CI2N L={Lp} W={Wp}
M7 net4 latch3 0 0 NMOS_CI2N L={Ln} W={Wn}
M8 net2 vinn net4 net4 NMOS_CI2N L={Ln} W={Wn}
M9 net1 vinp net4 net4 NMOS_CI2N L={Ln} W={Wn}
M10 net1 vrefn net4 net4 NMOS_CI2N L={Ln} W={Wn}
M11 net2 vrefp net4 net4 NMOS_CI2N L={Ln} W={Wn}
M12 vout__p vout__n net2 net2 NMOS_CI2N L={Ln} W={Wn}
M13 vout__n vout__p net1 net1 NMOS_CI2N L={Ln} W={Wn}
* supply rails (added; not part of the CI2N netlist)
Vsup_vdd_ vdd_ 0 {VDD}
.op
.end
