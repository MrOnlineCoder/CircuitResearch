* CI2N circuit from experiments/03-hybrid/results/claude-sonnet-5.5-hybrid/golden/050.json
* ckt_type: Bandgap
* generated by ci2n_to_spice.py
* ---- placeholder values: CI2N netlists carry topology only; edit as needed ----
.param VDD=1.8 VSS=0
.param Rval=10k Cval=1p Ival=10u Vval=0.9
.param Wn=1u Ln=180n Wp=2u Lp=180n Aol=1e5
.model NMOS_CI2N NMOS (level=1 VTO=0.45 KP=200u LAMBDA=0.05)
.model PMOS_CI2N PMOS (level=1 VTO=-0.45 KP=80u LAMBDA=0.05)
.model NPN_CI2N NPN (Is=1e-16 Bf=100 Vaf=50)
.model PNP_CI2N PNP (Is=1e-16 Bf=50 Vaf=50)
.model D_CI2N D (Is=1e-14)

.subckt DISO_AMP inp inn out
E1 out 0 inp inn {Aol}
.ends DISO_AMP

X1 net3 net1 net4 DISO_AMP
R1 net4 net3 {Rval}
R2 net4 net1 {Rval}
R3 net1 net2 {Rval}
Q1 0 0 net3 PNP_CI2N
Q2 0 0 net2 PNP_CI2N
.op
.end
