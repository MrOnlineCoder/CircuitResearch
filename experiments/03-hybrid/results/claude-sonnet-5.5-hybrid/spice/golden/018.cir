* CI2N circuit from experiments/03-hybrid/results/claude-sonnet-5.5-hybrid/golden/018.json
* ckt_type: LDO
* generated by ci2n_to_spice.py
* ---- placeholder values: CI2N netlists carry topology only; edit as needed ----
.param VDD=1.8 VSS=0
.param Rval=10k Cval=1p Ival=10u Vval=0.9
.param Wn=1u Ln=180n Wp=2u Lp=180n Aol=1e5
.model NMOS_CI2N NMOS (level=1 VTO=0.45 KP=200u LAMBDA=0.05)
.model PMOS_CI2N PMOS (level=1 VTO=-0.45 KP=80u LAMBDA=0.05)
.model NPN_CI2N NPN (Is=1e-16 Bf=100 Vaf=50)
.model PNP_CI2N PNP (Is=1e-16 Bf=50 Vaf=50)
.model D_CI2N D (Is=1e-14)

M1 net6 net17 0 0 NMOS_CI2N L={Ln} W={Wn}
M2 net17 net17 0 0 NMOS_CI2N L={Ln} W={Wn}
M3 net1 net1 0 0 NMOS_CI2N L={Ln} W={Wn}
M4 net9 net1 0 0 NMOS_CI2N L={Ln} W={Wn}
M5 net11 net13 net9 net9 NMOS_CI2N L={Ln} W={Wn}
M6 net8 net10 net9 net9 NMOS_CI2N L={Ln} W={Wn}
M7 net5 net6 net7 net7 PMOS_CI2N L={Lp} W={Wp}
M8 net6 net6 net28 net28 PMOS_CI2N L={Lp} W={Wp}
M9 net17 net11 net7 net7 PMOS_CI2N L={Lp} W={Wp}
M10 net11 net8 net7 net7 PMOS_CI2N L={Lp} W={Wp}
M11 net8 net8 net7 net7 PMOS_CI2N L={Lp} W={Wp}
R1 net6 net7 {Rval}
R2 net28 net7 {Rval}
R3 net11 net31 {Rval}
R4 net5 net3 {Rval}
R5 net3 0 {Rval}
C1 net3 net5 {Cval}
C2 net31 net5 {Cval}
.op
.end
