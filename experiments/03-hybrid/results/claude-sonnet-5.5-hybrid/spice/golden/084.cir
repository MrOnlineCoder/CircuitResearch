* CI2N circuit from experiments/03-hybrid/results/claude-sonnet-5.5-hybrid/golden/084.json
* ckt_type: DISO-Amplifier
* generated by ci2n_to_spice.py
* ---- placeholder values: CI2N netlists carry topology only; edit as needed ----
.param VDD=1.8 VSS=0
.param Rval=10k Cval=1p Ival=10u Vval=0.9
.param Wn=1u Ln=180n Wp=2u Lp=180n Aol=1e5
.model NMOS_CI2N NMOS (level=1 VTO=0.45 KP=200u LAMBDA=0.05)
.model PMOS_CI2N PMOS (level=1 VTO=-0.45 KP=80u LAMBDA=0.05)
.model NPN_CI2N NPN (Is=1e-16 Bf=100 Vaf=50)
.model PNP_CI2N PNP (Is=1e-16 Bf=50 Vaf=50)
.model D_CI2N D (Is=1e-14)

M1 net15 net15 0 0 NMOS_CI2N L={Ln} W={Wn}
M2 OUT VBias5 net18 net18 NMOS_CI2N L={Ln} W={Wn}
M3 net9 net8 0 0 NMOS_CI2N L={Ln} W={Wn}
M4 net8 net8 0 0 NMOS_CI2N L={Ln} W={Wn}
M5 net3 net9 VDD VDD PMOS_CI2N L={Lp} W={Wp}
M6 0 net15 net18 net18 PMOS_CI2N L={Lp} W={Wp}
M7 OUT VBias4 net3 net3 PMOS_CI2N L={Lp} W={Wp}
M8 net12 VBias1 VDD VDD PMOS_CI2N L={Lp} W={Wp}
M9 net21 IN1 net12 net12 PMOS_CI2N L={Lp} W={Wp}
M10 net8 VBias2 net21 net21 PMOS_CI2N L={Lp} W={Wp}
M11 net15 VBias3 net20 net20 PMOS_CI2N L={Lp} W={Wp}
M12 net9 net9 VDD VDD PMOS_CI2N L={Lp} W={Wp}
M13 net20 IN2 net12 net12 PMOS_CI2N L={Lp} W={Wp}
C1 OUT 0 {Cval}
* supply rails (added; not part of the CI2N netlist)
Vsup_VDD VDD 0 {VDD}
.op
.end
