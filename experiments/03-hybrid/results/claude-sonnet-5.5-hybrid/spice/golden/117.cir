* CI2N circuit from experiments/03-hybrid/results/claude-sonnet-5.5-hybrid/golden/117.json
* ckt_type: DISO-Amplifier
* generated by ci2n_to_spice.py
* renamed nets: vin+ -> vin_p, vin- -> vin_n
* ---- placeholder values: CI2N netlists carry topology only; edit as needed ----
.param VDD=1.8 VSS=0
.param Rval=10k Cval=1p Ival=10u Vval=0.9
.param Wn=1u Ln=180n Wp=2u Lp=180n Aol=1e5
.model NMOS_CI2N NMOS (level=1 VTO=0.45 KP=200u LAMBDA=0.05)
.model PMOS_CI2N PMOS (level=1 VTO=-0.45 KP=80u LAMBDA=0.05)
.model NPN_CI2N NPN (Is=1e-16 Bf=100 Vaf=50)
.model PNP_CI2N PNP (Is=1e-16 Bf=50 Vaf=50)
.model D_CI2N D (Is=1e-14)

M1 net3 net3 0 net5 NMOS_CI2N L={Ln} W={Wn}
M2 net4 vin_p net2 net2 NMOS_CI2N L={Ln} W={Wn}
M3 net1 vin_n net2 net2 NMOS_CI2N L={Ln} W={Wn}
M4 net2 net5 0 0 NMOS_CI2N L={Ln} W={Wn}
M5 net4 net1 VDD VDD PMOS_CI2N L={Lp} W={Wp}
M6 net1 net1 VDD VDD PMOS_CI2N L={Lp} W={Wp}
I1 VDD net3 {Ival}
C1 net4 0 {Cval}
* supply rails (added; not part of the CI2N netlist)
Vsup_VDD VDD 0 {VDD}
.op
.end
