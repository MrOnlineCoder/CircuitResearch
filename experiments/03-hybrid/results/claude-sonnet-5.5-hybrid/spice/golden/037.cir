* CI2N circuit from experiments/03-hybrid/results/claude-sonnet-5.5-hybrid/golden/037.json
* ckt_type: DIDO-Amplifier
* generated by ci2n_to_spice.py
* renamed nets: vdd! -> vdd_
* ---- placeholder values: CI2N netlists carry topology only; edit as needed ----
.param VDD=1.8 VSS=0
.param Rval=10k Cval=1p Ival=10u Vval=0.9
.param Wn=1u Ln=180n Wp=2u Lp=180n Aol=1e5
.model NMOS_CI2N NMOS (level=1 VTO=0.45 KP=200u LAMBDA=0.05)
.model PMOS_CI2N PMOS (level=1 VTO=-0.45 KP=80u LAMBDA=0.05)
.model NPN_CI2N NPN (Is=1e-16 Bf=100 Vaf=50)
.model PNP_CI2N PNP (Is=1e-16 Bf=50 Vaf=50)
.model D_CI2N D (Is=1e-14)

M1 voutp vpb2 net5 net5 PMOS_CI2N L={Lp} W={Wp}
M2 voutn vpb2 net4 net4 PMOS_CI2N L={Lp} W={Wp}
M3 net5 vpb1 vdd_ vdd_ PMOS_CI2N L={Lp} W={Wp}
M4 net4 vpb1 vdd_ vdd_ PMOS_CI2N L={Lp} W={Wp}
M5 net1 vnb1 0 0 NMOS_CI2N L={Ln} W={Wn}
M6 net5 vin net1 net1 NMOS_CI2N L={Ln} W={Wn}
M7 net4 vip net1 net1 NMOS_CI2N L={Ln} W={Wn}
M8 net3 vnb11 0 0 NMOS_CI2N L={Ln} W={Wn}
M9 net2 vnb11 0 0 NMOS_CI2N L={Ln} W={Wn}
M10 voutp vnb2 net3 net3 NMOS_CI2N L={Ln} W={Wn}
M11 voutn vnb2 net2 net2 NMOS_CI2N L={Ln} W={Wn}
C1 voutp 0 {Cval}
C2 voutn 0 {Cval}
* supply rails (added; not part of the CI2N netlist)
Vsup_vdd_ vdd_ 0 {VDD}
.op
.end
