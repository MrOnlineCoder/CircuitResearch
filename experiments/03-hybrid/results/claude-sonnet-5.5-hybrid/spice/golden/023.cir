* CI2N circuit from experiments/03-hybrid/results/claude-sonnet-5.5-hybrid/golden/023.json
* ckt_type: Comparator
* generated by ci2n_to_spice.py
* ---- placeholder values: CI2N netlists carry topology only; edit as needed ----
.param VDD=1.8 VSS=0
.param Rval=10k Cval=1p Ival=10u Vval=0.9
.param Wn=1u Ln=180n Wp=2u Lp=180n Aol=1e5
.model NMOS_CI2N NMOS (level=1 VTO=0.45 KP=200u LAMBDA=0.05)
.model PMOS_CI2N PMOS (level=1 VTO=-0.45 KP=80u LAMBDA=0.05)
.model NPN_CI2N NPN (Is=1e-16 Bf=100 Vaf=50)
.model PNP_CI2N PNP (Is=1e-16 Bf=50 Vaf=50)
.model D_CI2N D (Is=1e-14)

M1 net5 CLK net2 net2 PMOS_CI2N L={Lp} W={Wp}
M2 net4 CLK net2 net2 PMOS_CI2N L={Lp} W={Wp}
M3 net3 CLK net2 net2 PMOS_CI2N L={Lp} W={Wp}
M4 OUTP OUTN net1 net1 PMOS_CI2N L={Lp} W={Wp}
M5 OUTN OUTP net1 net1 PMOS_CI2N L={Lp} W={Wp}
M6 net1 net3 net2 net2 PMOS_CI2N L={Lp} W={Wp}
M7 net6 CLK 0 0 NMOS_CI2N L={Ln} W={Wn}
M8 net3 CLK 0 0 NMOS_CI2N L={Ln} W={Wn}
M9 OUTN net4 0 0 NMOS_CI2N L={Ln} W={Wn}
M10 OUTP OUTN 0 0 NMOS_CI2N L={Ln} W={Wn}
M11 OUTN OUTP 0 0 NMOS_CI2N L={Ln} W={Wn}
M12 OUTP net5 0 0 NMOS_CI2N L={Ln} W={Wn}
M13 net5 VINP net6 net6 NMOS_CI2N L={Ln} W={Wn}
M14 net4 VINN net6 net6 NMOS_CI2N L={Ln} W={Wn}
.op
.end
