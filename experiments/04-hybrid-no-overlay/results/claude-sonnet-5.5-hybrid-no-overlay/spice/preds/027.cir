* CI2N circuit from experiments/04-hybrid-no-overlay/results/claude-sonnet-5.5-hybrid-no-overlay/preds/027.json
* generated by ci2n_to_spice.py
* ---- placeholder values: CI2N netlists carry topology only; edit as needed ----
.param VDD=1.8 VSS=0
.param Rval=10k Cval=1p Ival=10u Vval=0.9
.param Wn=1u Ln=180n Wp=2u Lp=180n Aol=1e5
.model NMOS_CI2N NMOS (level=1 VTO=0.45 KP=200u LAMBDA=0.05)
.model PMOS_CI2N PMOS (level=1 VTO=-0.45 KP=80u LAMBDA=0.05)
.model NPN_CI2N NPN (Is=1e-16 Bf=100 Vaf=50)
.model PNP_CI2N PNP (Is=1e-16 Bf=50 Vaf=50)
.model D_CI2N D (Is=1e-14)

M1 net1 gA VDD VDD PMOS_CI2N L={Lp} W={Wp}
M2 net2 gA VDD VDD PMOS_CI2N L={Lp} W={Wp}
M3 net3 gA VDD VDD PMOS_CI2N L={Lp} W={Wp}
M4 net4 gA VDD VDD PMOS_CI2N L={Lp} W={Wp}
M5 net5 gB net4 net4 PMOS_CI2N L={Lp} W={Wp}
M6 net6 gB net1 net1 PMOS_CI2N L={Lp} W={Wp}
M7 net7 gB net2 net2 PMOS_CI2N L={Lp} W={Wp}
M8 gB gB VDD VDD PMOS_CI2N L={Lp} W={Wp}
M9 gA gB net3 net3 PMOS_CI2N L={Lp} W={Wp}
R1 net5 nR {Rval}
M10 gB net5 net8 net8 NMOS_CI2N L={Ln} W={Wn}
M11 gA net6 net9 net9 NMOS_CI2N L={Ln} W={Wn}
M12 nR net5 net10 net10 NMOS_CI2N L={Ln} W={Wn}
M13 net11 net5 net12 net12 NMOS_CI2N L={Ln} W={Wn}
M14 net6 net6 0 0 NMOS_CI2N L={Ln} W={Wn}
M15 net8 nR 0 0 NMOS_CI2N L={Ln} W={Wn}
M16 net10 nR 0 0 NMOS_CI2N L={Ln} W={Wn}
M17 net12 nR 0 0 NMOS_CI2N L={Ln} W={Wn}
R2 net9 0 {Rval}
* supply rails (added; not part of the CI2N netlist)
Vsup_VDD VDD 0 {VDD}
.op
.end
