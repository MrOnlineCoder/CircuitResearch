* CI2N circuit from experiments/04-hybrid-no-overlay/results/claude-sonnet-5.5-hybrid-no-overlay/preds/038.json
* generated by ci2n_to_spice.py
* ---- placeholder values: CI2N netlists carry topology only; edit as needed ----
.param VDD=1.8 VSS=0
.param Rval=10k Cval=1p Ival=10u Vval=0.9
.param Wn=1u Ln=180n Wp=2u Lp=180n Aol=1e5
.model NMOS_CI2N NMOS (level=1 VTO=0.45 KP=200u LAMBDA=0.05)
.model PMOS_CI2N PMOS (level=1 VTO=-0.45 KP=80u LAMBDA=0.05)
.model NPN_CI2N NPN (Is=1e-16 Bf=100 Vaf=50)
.model PNP_CI2N PNP (Is=1e-16 Bf=50 Vaf=50)
.model D_CI2N D (Is=1e-14)

M1 nB n_latch VDD VDD PMOS_CI2N L={Lp} W={Wp}
M2 nOm n_latch VDD VDD PMOS_CI2N L={Lp} W={Wp}
M3 nOp nOm VDD VDD PMOS_CI2N L={Lp} W={Wp}
M4 nOp n_latch VDD VDD PMOS_CI2N L={Lp} W={Wp}
M5 nOm nOp VDD VDD PMOS_CI2N L={Lp} W={Wp}
M6 nA n_latch VDD VDD PMOS_CI2N L={Lp} W={Wp}
M7 nOm nOp nA nA NMOS_CI2N L={Ln} W={Wn}
M8 nOp nOm nB nB NMOS_CI2N L={Ln} W={Wn}
M9 nB nVrp nT nT NMOS_CI2N L={Ln} W={Wn}
M10 nA nVrn nT nT NMOS_CI2N L={Ln} W={Wn}
M11 nA nVip nT nT NMOS_CI2N L={Ln} W={Wn}
M12 nB nVin nT nT NMOS_CI2N L={Ln} W={Wn}
M13 nT n_latch 0 0 NMOS_CI2N L={Ln} W={Wn}
* supply rails (added; not part of the CI2N netlist)
Vsup_VDD VDD 0 {VDD}
.op
.end
