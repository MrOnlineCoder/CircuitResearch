* CI2N circuit from experiments/04-hybrid-no-overlay/results/claude-sonnet-5.5-hybrid-no-overlay/preds/042.json
* generated by ci2n_to_spice.py
* ---- placeholder values: CI2N netlists carry topology only; edit as needed ----
.param VDD=1.8 VSS=0
.param Rval=10k Cval=1p Ival=10u Vval=0.9
.param Wn=1u Ln=180n Wp=2u Lp=180n Aol=1e5
.model NMOS_CI2N NMOS (level=1 VTO=0.45 KP=200u LAMBDA=0.05)
.model PMOS_CI2N PMOS (level=1 VTO=-0.45 KP=80u LAMBDA=0.05)
.model NPN_CI2N NPN (Is=1e-16 Bf=100 Vaf=50)
.model PNP_CI2N PNP (Is=1e-16 Bf=50 Vaf=50)
.model D_CI2N D (Is=1e-14)

M1 net1 net1 net2 net3 PMOS_CI2N L={Lp} W={Wp}
M2 net4 net4 net2 net2 PMOS_CI2N L={Lp} W={Wp}
M3 net5 net6 net2 net2 PMOS_CI2N L={Lp} W={Wp}
M4 net6 net4 net2 net2 PMOS_CI2N L={Lp} W={Wp}
M5 net6 net4 net2 net2 PMOS_CI2N L={Lp} W={Wp}
M6 n6 n6 net1 net8 PMOS_CI2N L={Lp} W={Wp}
I1 net2 net9 {Ival}
M7 net4 net10 tail net11 NMOS_CI2N L={Ln} W={Wn}
M8 net6 net12 tail tail NMOS_CI2N L={Ln} W={Wn}
C1 net13 net5 {Cval}
M9 net6 g13 net13 net14 PMOS_CI2N L={Lp} W={Wp}
M10 n7d g13 n6 net15 PMOS_CI2N L={Lp} W={Wp}
M11 net9 net9 0 net16 NMOS_CI2N L={Ln} W={Wn}
M12 n7d net9 0 0 NMOS_CI2N L={Ln} W={Wn}
M13 net6 net9 0 0 NMOS_CI2N L={Ln} W={Wn}
M14 net5 net9 0 net20 NMOS_CI2N L={Ln} W={Wn}
M15 tail net9 0 0 NMOS_CI2N L={Ln} W={Wn}
.op
.end
