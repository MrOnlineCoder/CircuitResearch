* CI2N circuit from experiments/04-hybrid-no-overlay/results/claude-sonnet-5.5-hybrid-no-overlay/preds/054.json
* generated by ci2n_to_spice.py
* ---- placeholder values: CI2N netlists carry topology only; edit as needed ----
.param VDD=1.8 VSS=0
.param Rval=10k Cval=1p Ival=10u Vval=0.9
.param Wn=1u Ln=180n Wp=2u Lp=180n Aol=1e5
.model NMOS_CI2N NMOS (level=1 VTO=0.45 KP=200u LAMBDA=0.05)
.model PMOS_CI2N PMOS (level=1 VTO=-0.45 KP=80u LAMBDA=0.05)
.model NPN_CI2N NPN (Is=1e-16 Bf=100 Vaf=50)
.model PNP_CI2N PNP (Is=1e-16 Bf=50 Vaf=50)
.model D_CI2N D (Is=1e-14)

M1 net1 net1 net2 net2 PMOS_CI2N L={Lp} W={Wp}
M2 net3 net1 net2 net2 PMOS_CI2N L={Lp} W={Wp}
M3 net4 net4 net2 net2 PMOS_CI2N L={Lp} W={Wp}
M4 net5 net4 net2 net2 PMOS_CI2N L={Lp} W={Wp}
M5 net6 net7 net3 net3 PMOS_CI2N L={Lp} W={Wp}
M6 net7 net7 net1 net1 PMOS_CI2N L={Lp} W={Wp}
M7 newD net9 net5 net5 PMOS_CI2N L={Lp} W={Wp}
M8 net9 net9 net4 net4 PMOS_CI2N L={Lp} W={Wp}
M9 net7 net10 net8 net8 NMOS_CI2N L={Ln} W={Wn}
M10 net9 net11 net8 net8 NMOS_CI2N L={Ln} W={Wn}
M11 net6 newD net12 net12 NMOS_CI2N L={Ln} W={Wn}
M12 newD newD newX newX NMOS_CI2N L={Ln} W={Wn}
M13 net8 newI net13 net13 NMOS_CI2N L={Ln} W={Wn}
M14 newI newI net13 net13 NMOS_CI2N L={Ln} W={Wn}
M15 net12 newX net13 net13 NMOS_CI2N L={Ln} W={Wn}
M16 newX newX net13 net13 NMOS_CI2N L={Ln} W={Wn}
.op
.end
