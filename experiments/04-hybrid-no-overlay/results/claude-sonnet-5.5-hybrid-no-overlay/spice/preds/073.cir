* CI2N circuit from experiments/04-hybrid-no-overlay/results/claude-sonnet-5.5-hybrid-no-overlay/preds/073.json
* generated by ci2n_to_spice.py
* ---- placeholder values: CI2N netlists carry topology only; edit as needed ----
.param VDD=1.8 VSS=0
.param Rval=10k Cval=1p Ival=10u Vval=0.9
.param Wn=1u Ln=180n Wp=2u Lp=180n Aol=1e5
.model NMOS_CI2N NMOS (level=1 VTO=0.45 KP=200u LAMBDA=0.05)
.model PMOS_CI2N PMOS (level=1 VTO=-0.45 KP=80u LAMBDA=0.05)
.model NPN_CI2N NPN (Is=1e-16 Bf=100 Vaf=50)
.model PNP_CI2N PNP (Is=1e-16 Bf=50 Vaf=50)
.model D_CI2N D (Is=1e-14)

M1 net1 net2 VDD VDD PMOS_CI2N L={Lp} W={Wp}
M2 net3 net3 VDD VDD PMOS_CI2N L={Lp} W={Wp}
M3 net4 net4 VDD VDD PMOS_CI2N L={Lp} W={Wp}
M4 netP net3 VDD VDD PMOS_CI2N L={Lp} W={Wp}
M5 netN net4 VDD VDD PMOS_CI2N L={Lp} W={Wp}
M6 net6 net7 VDD VDD PMOS_CI2N L={Lp} W={Wp}
M7 net8 net9 VDD VDD PMOS_CI2N L={Lp} W={Wp}
M8 netN net10 net8 net8 PMOS_CI2N L={Lp} W={Wp}
M9 netP net11 net6 net6 PMOS_CI2N L={Lp} W={Wp}
M10 netA net12 net1 net1 PMOS_CI2N L={Lp} W={Wp}
M11 netB net13 net1 net1 PMOS_CI2N L={Lp} W={Wp}
C1 netN 0 {Cval}
C2 netP 0 {Cval}
M12 netP net14 netB netB NMOS_CI2N L={Ln} W={Wn}
M13 netN net15 netA netA NMOS_CI2N L={Ln} W={Wn}
M14 netP netA 0 0 NMOS_CI2N L={Ln} W={Wn}
M15 net3 netA 0 0 NMOS_CI2N L={Ln} W={Wn}
M16 netA netA 0 0 NMOS_CI2N L={Ln} W={Wn}
M17 netA net16 0 0 NMOS_CI2N L={Ln} W={Wn}
M18 netB net16 0 0 NMOS_CI2N L={Ln} W={Wn}
M19 netB netB 0 0 NMOS_CI2N L={Ln} W={Wn}
M20 netN netB 0 0 NMOS_CI2N L={Ln} W={Wn}
M21 net4 netB 0 0 NMOS_CI2N L={Ln} W={Wn}
* supply rails (added; not part of the CI2N netlist)
Vsup_VDD VDD 0 {VDD}
.op
.end
