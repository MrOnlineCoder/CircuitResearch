* CI2N circuit from experiments/04-hybrid-no-overlay/results/claude-sonnet-5.5-hybrid-no-overlay/preds/087.json
* generated by ci2n_to_spice.py
* ---- placeholder values: CI2N netlists carry topology only; edit as needed ----
.param VDD=1.8 VSS=0
.param Rval=10k Cval=1p Ival=10u Vval=0.9
.param Wn=1u Ln=180n Wp=2u Lp=180n Aol=1e5
.model NMOS_CI2N NMOS (level=1 VTO=0.45 KP=200u LAMBDA=0.05)
.model PMOS_CI2N PMOS (level=1 VTO=-0.45 KP=80u LAMBDA=0.05)
.model NPN_CI2N NPN (Is=1e-16 Bf=100 Vaf=50)
.model PNP_CI2N PNP (Is=1e-16 Bf=50 Vaf=50)
.model D_CI2N D (Is=1e-14)

M1 net1 net2 VDD VDD PMOS_CI2N L={Lp} W={Wp}
M2 net3 nC VDD VDD PMOS_CI2N L={Lp} W={Wp}
M3 net4 net7 VDD VDD PMOS_CI2N L={Lp} W={Wp}
M4 net4 net7 VDD VDD PMOS_CI2N L={Lp} W={Wp}
M5 net6 net7 VDD VDD PMOS_CI2N L={Lp} W={Wp}
M6 net8 nC VDD VDD PMOS_CI2N L={Lp} W={Wp}
M7 nA bpc net4 net4 PMOS_CI2N L={Lp} W={Wp}
M8 net7 bpc net6 net6 PMOS_CI2N L={Lp} W={Wp}
M9 net9 bpc net3 net3 PMOS_CI2N L={Lp} W={Wp}
M10 nB bpc net4 net4 PMOS_CI2N L={Lp} W={Wp}
M11 nC bpc net8 net8 PMOS_CI2N L={Lp} W={Wp}
R1 net1 bn {Rval}
R2 net7 bpc {Rval}
M12 net4 net10 net11 net11 NMOS_CI2N L={Ln} W={Wn}
M13 net4 net12 net11 net11 NMOS_CI2N L={Ln} W={Wn}
M14 bn net1 net13 net13 NMOS_CI2N L={Ln} W={Wn}
M15 bpc net1 net14 net14 NMOS_CI2N L={Ln} W={Wn}
M16 net9 net1 net15 net15 NMOS_CI2N L={Ln} W={Wn}
M17 nC net1 net16 net16 NMOS_CI2N L={Ln} W={Wn}
M18 net11 net1 net17 net17 NMOS_CI2N L={Ln} W={Wn}
M19 nA net1 net18 net18 NMOS_CI2N L={Ln} W={Wn}
M20 nB net1 net19 net19 NMOS_CI2N L={Ln} W={Wn}
M21 net17 bn 0 0 NMOS_CI2N L={Ln} W={Wn}
M22 net16 nB 0 0 NMOS_CI2N L={Ln} W={Wn}
M23 net13 bn 0 0 NMOS_CI2N L={Ln} W={Wn}
M24 net18 nA 0 0 NMOS_CI2N L={Ln} W={Wn}
M25 net19 nB 0 0 NMOS_CI2N L={Ln} W={Wn}
M26 net15 nA 0 0 NMOS_CI2N L={Ln} W={Wn}
M27 net14 bn 0 0 NMOS_CI2N L={Ln} W={Wn}
* supply rails (added; not part of the CI2N netlist)
Vsup_VDD VDD 0 {VDD}
.op
.end
