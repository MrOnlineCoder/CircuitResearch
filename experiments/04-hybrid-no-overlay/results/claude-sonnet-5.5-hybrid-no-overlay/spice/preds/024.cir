* CI2N circuit from experiments/04-hybrid-no-overlay/results/claude-sonnet-5.5-hybrid-no-overlay/preds/024.json
* generated by ci2n_to_spice.py
* ---- placeholder values: CI2N netlists carry topology only; edit as needed ----
.param VDD=1.8 VSS=0
.param Rval=10k Cval=1p Ival=10u Vval=0.9
.param Wn=1u Ln=180n Wp=2u Lp=180n Aol=1e5
.model NMOS_CI2N NMOS (level=1 VTO=0.45 KP=200u LAMBDA=0.05)
.model PMOS_CI2N PMOS (level=1 VTO=-0.45 KP=80u LAMBDA=0.05)
.model NPN_CI2N NPN (Is=1e-16 Bf=100 Vaf=50)
.model PNP_CI2N PNP (Is=1e-16 Bf=50 Vaf=50)
.model D_CI2N D (Is=1e-14)

M1 net1 nOUT VDD VDD PMOS_CI2N L={Lp} W={Wp}
M2 net2 nOUT VDD VDD PMOS_CI2N L={Lp} W={Wp}
M3 net3 0 VDD VDD PMOS_CI2N L={Lp} W={Wp}
M4 net4 nOUT VDD VDD PMOS_CI2N L={Lp} W={Wp}
M5 net5 nOUT VDD VDD PMOS_CI2N L={Lp} W={Wp}
M6 net6 nOUT VDD VDD PMOS_CI2N L={Lp} W={Wp}
M7 nG12 nS net2 net2 PMOS_CI2N L={Lp} W={Wp}
M8 nB nS net4 net4 PMOS_CI2N L={Lp} W={Wp}
M9 net7 nS net1 net1 PMOS_CI2N L={Lp} W={Wp}
M10 net8 nS net6 net6 PMOS_CI2N L={Lp} W={Wp}
M11 net9 0 net3 net3 PMOS_CI2N L={Lp} W={Wp}
M12 net10 nS net5 net5 PMOS_CI2N L={Lp} W={Wp}
M13 nS nS VDD VDD PMOS_CI2N L={Lp} W={Wp}
M14 net11 net12 VDD VDD PMOS_CI2N L={Lp} W={Wp}
M15 net12 net12 VDD VDD PMOS_CI2N L={Lp} W={Wp}
M16 nOUT net12 VDD VDD PMOS_CI2N L={Lp} W={Wp}
R1 nB nD {Rval}
R2 net7 nC {Rval}
M17 nX nD net11 net11 PMOS_CI2N L={Lp} W={Wp}
M18 nY nC net11 net11 PMOS_CI2N L={Lp} W={Wp}
M19 net9 nS 0 0 NMOS_CI2N L={Ln} W={Wn}
M20 net9 nOUT 0 0 NMOS_CI2N L={Ln} W={Wn}
R3 net10 0 {Rval}
R4 nD 0 {Rval}
R5 nC 0 {Rval}
R6 nB net13 {Rval}
R7 net14 nX {Rval}
C1 nOUT net14 {Cval}
M21 net9 nG12 0 0 NMOS_CI2N L={Ln} W={Wn}
M22 nG12 nG12 0 0 NMOS_CI2N L={Ln} W={Wn}
M23 nS nG12 0 0 NMOS_CI2N L={Ln} W={Wn}
M24 net12 net8 0 0 NMOS_CI2N L={Ln} W={Wn}
M25 net8 net8 0 0 NMOS_CI2N L={Ln} W={Wn}
M26 nY nY 0 0 NMOS_CI2N L={Ln} W={Wn}
M27 nX nY 0 0 NMOS_CI2N L={Ln} W={Wn}
M28 nOUT nX 0 0 NMOS_CI2N L={Ln} W={Wn}
Q1 0 0 net7 PNP_CI2N
Q2 0 0 net13 PNP_CI2N
* supply rails (added; not part of the CI2N netlist)
Vsup_VDD VDD 0 {VDD}
.op
.end
