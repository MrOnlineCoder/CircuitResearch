* CI2N circuit from experiments/04-hybrid-no-overlay/results/claude-sonnet-5.5-hybrid-no-overlay/preds/020.json
* generated by ci2n_to_spice.py
* ---- placeholder values: CI2N netlists carry topology only; edit as needed ----
.param VDD=1.8 VSS=0
.param Rval=10k Cval=1p Ival=10u Vval=0.9
.param Wn=1u Ln=180n Wp=2u Lp=180n Aol=1e5
.model NMOS_CI2N NMOS (level=1 VTO=0.45 KP=200u LAMBDA=0.05)
.model PMOS_CI2N PMOS (level=1 VTO=-0.45 KP=80u LAMBDA=0.05)
.model NPN_CI2N NPN (Is=1e-16 Bf=100 Vaf=50)
.model PNP_CI2N PNP (Is=1e-16 Bf=50 Vaf=50)
.model D_CI2N D (Is=1e-14)

M1 net1 net2 VDD VDD PMOS_CI2N L={Lp} W={Wp}
M2 net3 net4 VDD VDD PMOS_CI2N L={Lp} W={Wp}
M3 net5 net6 VDD VDD PMOS_CI2N L={Lp} W={Wp}
M4 net15 net8 VDD VDD PMOS_CI2N L={Lp} W={Wp}
M5 net9 net10 VDD VDD PMOS_CI2N L={Lp} W={Wp}
M6 net14 net11 net1 net1 PMOS_CI2N L={Lp} W={Wp}
M7 net13 net12 net3 net3 PMOS_CI2N L={Lp} W={Wp}
C1 net9 net13 {Cval}
C2 net14 net15 {Cval}
M8 net16 net13 net5 net5 PMOS_CI2N L={Lp} W={Wp}
M9 net18 net14 net5 net5 PMOS_CI2N L={Lp} W={Wp}
M10 0 net13 0 0 PMOS_CI2N L={Lp} W={Wp}
M11 0 net14 0 0 PMOS_CI2N L={Lp} W={Wp}
M12 net14 net23 net18 net18 NMOS_CI2N L={Ln} W={Wn}
M13 net13 net24 net16 net16 NMOS_CI2N L={Ln} W={Wn}
M14 net15 net18 0 0 NMOS_CI2N L={Ln} W={Wn}
M15 net9 net16 0 0 NMOS_CI2N L={Ln} W={Wn}
M16 net18 net27 0 0 NMOS_CI2N L={Ln} W={Wn}
M17 net16 net28 0 0 NMOS_CI2N L={Ln} W={Wn}
* supply rails (added; not part of the CI2N netlist)
Vsup_VDD VDD 0 {VDD}
.op
.end
