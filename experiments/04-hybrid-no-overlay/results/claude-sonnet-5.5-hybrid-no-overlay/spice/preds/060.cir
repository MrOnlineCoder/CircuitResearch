* CI2N circuit from experiments/04-hybrid-no-overlay/results/claude-sonnet-5.5-hybrid-no-overlay/preds/060.json
* generated by ci2n_to_spice.py
* ---- placeholder values: CI2N netlists carry topology only; edit as needed ----
.param VDD=1.8 VSS=0
.param Rval=10k Cval=1p Ival=10u Vval=0.9
.param Wn=1u Ln=180n Wp=2u Lp=180n Aol=1e5
.model NMOS_CI2N NMOS (level=1 VTO=0.45 KP=200u LAMBDA=0.05)
.model PMOS_CI2N PMOS (level=1 VTO=-0.45 KP=80u LAMBDA=0.05)
.model NPN_CI2N NPN (Is=1e-16 Bf=100 Vaf=50)
.model PNP_CI2N PNP (Is=1e-16 Bf=50 Vaf=50)
.model D_CI2N D (Is=1e-14)

Q1 net1 net2 net3 PNP_CI2N
Q2 net4 net2 net3 PNP_CI2N
Q3 net5 net4 net3 PNP_CI2N
Q4 0 net1 net2 PNP_CI2N
R1 0 net6 {Rval}
Q5 net4 net7 net8 NPN_CI2N
Q6 net1 net9 net8 NPN_CI2N
Q7 net6 net6 net10 NPN_CI2N
Q8 net5 net6 net10 NPN_CI2N
Q9 net8 net6 net10 NPN_CI2N
.op
.end
