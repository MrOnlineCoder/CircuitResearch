* CI2N circuit from experiments/04-hybrid-no-overlay/results/claude-sonnet-5.5-hybrid-no-overlay/preds/065.json
* generated by ci2n_to_spice.py
* ---- placeholder values: CI2N netlists carry topology only; edit as needed ----
.param VDD=1.8 VSS=0
.param Rval=10k Cval=1p Ival=10u Vval=0.9
.param Wn=1u Ln=180n Wp=2u Lp=180n Aol=1e5
.model NMOS_CI2N NMOS (level=1 VTO=0.45 KP=200u LAMBDA=0.05)
.model PMOS_CI2N PMOS (level=1 VTO=-0.45 KP=80u LAMBDA=0.05)
.model NPN_CI2N NPN (Is=1e-16 Bf=100 Vaf=50)
.model PNP_CI2N PNP (Is=1e-16 Bf=50 Vaf=50)
.model D_CI2N D (Is=1e-14)

M1 nB nBias VDD VDD PMOS_CI2N L={Lp} W={Wp}
M2 net1 nBias VDD VDD PMOS_CI2N L={Lp} W={Wp}
M3 nA nBias VDD VDD PMOS_CI2N L={Lp} W={Wp}
M4 nB nA VDD VDD PMOS_CI2N L={Lp} W={Wp}
M5 nA nA VDD VDD PMOS_CI2N L={Lp} W={Wp}
M6 net2 net2 VDD VDD PMOS_CI2N L={Lp} W={Wp}
M7 net3 net2 VDD VDD PMOS_CI2N L={Lp} W={Wp}
M8 nOut nA VDD VDD PMOS_CI2N L={Lp} W={Wp}
M9 nG nG net3 net3 PMOS_CI2N L={Lp} W={Wp}
M10 nU nG net2 net2 PMOS_CI2N L={Lp} W={Wp}
R1 nOut nFB {Rval}
M11 nA nU nC nC NMOS_CI2N L={Ln} W={Wn}
M12 nL nFB net1 net1 PMOS_CI2N L={Lp} W={Wp}
M13 net4 net5 net1 net1 PMOS_CI2N L={Lp} W={Wp}
R2 nOut 0 {Rval}
R3 nFB 0 {Rval}
M14 nA nC 0 0 NMOS_CI2N L={Ln} W={Wn}
C1 nOut 0 {Cval}
M15 nG net6 nL nL NMOS_CI2N L={Ln} W={Wn}
M16 nU net6 net4 net4 NMOS_CI2N L={Ln} W={Wn}
C2 net4 nOut {Cval}
M17 net4 net7 0 0 NMOS_CI2N L={Ln} W={Wn}
M18 nL net7 0 0 NMOS_CI2N L={Ln} W={Wn}
M19 nC nB 0 0 NMOS_CI2N L={Ln} W={Wn}
M20 nB nB 0 0 NMOS_CI2N L={Ln} W={Wn}
* supply rails (added; not part of the CI2N netlist)
Vsup_VDD VDD 0 {VDD}
.op
.end
