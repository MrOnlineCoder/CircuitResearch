* CI2N circuit from experiments/04-hybrid-no-overlay/results/claude-sonnet-5.5-hybrid-no-overlay/preds/077.json
* generated by ci2n_to_spice.py
* ---- placeholder values: CI2N netlists carry topology only; edit as needed ----
.param VDD=1.8 VSS=0
.param Rval=10k Cval=1p Ival=10u Vval=0.9
.param Wn=1u Ln=180n Wp=2u Lp=180n Aol=1e5
.model NMOS_CI2N NMOS (level=1 VTO=0.45 KP=200u LAMBDA=0.05)
.model PMOS_CI2N PMOS (level=1 VTO=-0.45 KP=80u LAMBDA=0.05)
.model NPN_CI2N NPN (Is=1e-16 Bf=100 Vaf=50)
.model PNP_CI2N PNP (Is=1e-16 Bf=50 Vaf=50)
.model D_CI2N D (Is=1e-14)

Q1 net1 net2 net3 PNP_CI2N
Q2 nY nY net3 PNP_CI2N
Q3 net2 net2 net3 PNP_CI2N
Q4 nZ nY net3 PNP_CI2N
Q5 net3 net1 net5 NPN_CI2N
Q6 nY net6 net7 NPN_CI2N
Q7 nY net8 net9 NPN_CI2N
R1 net2 nA {Rval}
Q8 net1 net5 net10 NPN_CI2N
R2 net11 net1 {Rval}
Q9 net1 net11 net12 NPN_CI2N
Q10 net4 nZ net9 PNP_CI2N
Q11 net13 nZ net7 PNP_CI2N
C1 net1 net4 {Cval}
R3 net5 net10 {Rval}
R4 net11 net12 {Rval}
Q12 net12 net4 net14 NPN_CI2N
Q13 net3 net13 net15 NPN_CI2N
R5 net10 net16 {Rval}
Q14 net12 net14 new1 NPN_CI2N
Q15 net16 net12 net17 NPN_CI2N
Q16 net4 new1 net17 NPN_CI2N
Q17 net4 net15 net18 NPN_CI2N
Q18 nZ nA net19 NPN_CI2N
Q19 net13 net15 net20 NPN_CI2N
Q20 nA nA net17 NPN_CI2N
R6 net20 net17 {Rval}
R7 net14 net17 {Rval}
R8 net15 net17 {Rval}
R9 net19 net17 {Rval}
R10 net18 net17 {Rval}
R11 new1 net17 {Rval}
.op
.end
