* CI2N circuit from experiments/04-hybrid-no-overlay/results/claude-sonnet-5.5-hybrid-no-overlay/preds/063.json
* generated by ci2n_to_spice.py
* ---- placeholder values: CI2N netlists carry topology only; edit as needed ----
.param VDD=1.8 VSS=0
.param Rval=10k Cval=1p Ival=10u Vval=0.9
.param Wn=1u Ln=180n Wp=2u Lp=180n Aol=1e5
.model NMOS_CI2N NMOS (level=1 VTO=0.45 KP=200u LAMBDA=0.05)
.model PMOS_CI2N PMOS (level=1 VTO=-0.45 KP=80u LAMBDA=0.05)
.model NPN_CI2N NPN (Is=1e-16 Bf=100 Vaf=50)
.model PNP_CI2N PNP (Is=1e-16 Bf=50 Vaf=50)
.model D_CI2N D (Is=1e-14)

M1 net1 net2 VDD VDD PMOS_CI2N L={Lp} W={Wp}
M2 net3 net2 VDD VDD PMOS_CI2N L={Lp} W={Wp}
M3 net4 net2 VDD VDD PMOS_CI2N L={Lp} W={Wp}
M4 net5 net6 net4 net4 PMOS_CI2N L={Lp} W={Wp}
M5 net7 net8 net4 net4 PMOS_CI2N L={Lp} W={Wp}
M6 net9 net10 net5 net5 NMOS_CI2N L={Ln} W={Wn}
M7 net12 net11 net7 net7 NMOS_CI2N L={Ln} W={Wn}
C1 net9 net3 {Cval}
C2 net1 net12 {Cval}
M8 net1 net7 0 0 NMOS_CI2N L={Ln} W={Wn}
M9 net3 net5 0 0 NMOS_CI2N L={Ln} W={Wn}
M10 net5 net13 0 0 NMOS_CI2N L={Ln} W={Wn}
M11 net7 net13 0 0 NMOS_CI2N L={Ln} W={Wn}
M12 net14 net15 VDD VDD PMOS_CI2N L={Lp} W={Wp}
R1 net1 net16 {Rval}
M13 net13 net16 net14 net14 PMOS_CI2N L={Lp} W={Wp}
M14 net17 net18 net14 net14 PMOS_CI2N L={Lp} W={Wp}
R2 net3 net16 {Rval}
M15 net17 net17 0 0 NMOS_CI2N L={Ln} W={Wn}
M16 net13 net17 0 0 NMOS_CI2N L={Ln} W={Wn}
* supply rails (added; not part of the CI2N netlist)
Vsup_VDD VDD 0 {VDD}
.op
.end
