* CI2N circuit from experiments/04-hybrid-no-overlay/results/claude-sonnet-5.5-hybrid-no-overlay/preds/052.json
* generated by ci2n_to_spice.py
* ---- placeholder values: CI2N netlists carry topology only; edit as needed ----
.param VDD=1.8 VSS=0
.param Rval=10k Cval=1p Ival=10u Vval=0.9
.param Wn=1u Ln=180n Wp=2u Lp=180n Aol=1e5
.model NMOS_CI2N NMOS (level=1 VTO=0.45 KP=200u LAMBDA=0.05)
.model PMOS_CI2N PMOS (level=1 VTO=-0.45 KP=80u LAMBDA=0.05)
.model NPN_CI2N NPN (Is=1e-16 Bf=100 Vaf=50)
.model PNP_CI2N PNP (Is=1e-16 Bf=50 Vaf=50)
.model D_CI2N D (Is=1e-14)

M1 net1 net1 VDD net2 PMOS_CI2N L={Lp} W={Wp}
M2 tail net1 VDD VDD PMOS_CI2N L={Lp} W={Wp}
M3 net3 net1 VDD VDD PMOS_CI2N L={Lp} W={Wp}
M4 net4 net4 net1 net5 PMOS_CI2N L={Lp} W={Wp}
M5 net6 net7 tail tail PMOS_CI2N L={Lp} W={Wp}
M6 net9 net10 tail net11 PMOS_CI2N L={Lp} W={Wp}
M7 net12 net4 net9 net9 PMOS_CI2N L={Lp} W={Wp}
M8 mir net4 net6 net6 PMOS_CI2N L={Lp} W={Wp}
C1 net14 net3 {Cval}
R1 net12 net14 {Rval}
M9 net15 net15 net16 net16 NMOS_CI2N L={Ln} W={Wn}
M10 net4 net15 net16 net16 NMOS_CI2N L={Ln} W={Wn}
M11 net3 net12 net16 net16 NMOS_CI2N L={Ln} W={Wn}
M12 mir mir net17 net17 NMOS_CI2N L={Ln} W={Wn}
M13 net12 mir net18 net18 NMOS_CI2N L={Ln} W={Wn}
R2 net17 net16 {Rval}
R3 net18 net16 {Rval}
* supply rails (added; not part of the CI2N netlist)
Vsup_VDD VDD 0 {VDD}
.op
.end
