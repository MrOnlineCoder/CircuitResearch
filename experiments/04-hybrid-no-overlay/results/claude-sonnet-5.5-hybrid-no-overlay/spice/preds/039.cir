* CI2N circuit from experiments/04-hybrid-no-overlay/results/claude-sonnet-5.5-hybrid-no-overlay/preds/039.json
* generated by ci2n_to_spice.py
* ---- placeholder values: CI2N netlists carry topology only; edit as needed ----
.param VDD=1.8 VSS=0
.param Rval=10k Cval=1p Ival=10u Vval=0.9
.param Wn=1u Ln=180n Wp=2u Lp=180n Aol=1e5
.model NMOS_CI2N NMOS (level=1 VTO=0.45 KP=200u LAMBDA=0.05)
.model PMOS_CI2N PMOS (level=1 VTO=-0.45 KP=80u LAMBDA=0.05)
.model NPN_CI2N NPN (Is=1e-16 Bf=100 Vaf=50)
.model PNP_CI2N PNP (Is=1e-16 Bf=50 Vaf=50)
.model D_CI2N D (Is=1e-14)

M1 net1 VDD VDD VDD PMOS_CI2N L={Lp} W={Wp}
M2 VDD VDD VDD VDD PMOS_CI2N L={Lp} W={Wp}
M3 VDD VDD VDD VDD PMOS_CI2N L={Lp} W={Wp}
M4 VDD VDD VDD VDD PMOS_CI2N L={Lp} W={Wp}
M5 net2 VDD VDD VDD PMOS_CI2N L={Lp} W={Wp}
M6 net3 VDD VDD VDD PMOS_CI2N L={Lp} W={Wp}
M7 net1 net1 VDD VDD PMOS_CI2N L={Lp} W={Wp}
M8 VDD net1 VDD VDD PMOS_CI2N L={Lp} W={Wp}
M9 VDD VDD VDD VDD PMOS_CI2N L={Lp} W={Wp}
M10 VDD VDD VDD VDD PMOS_CI2N L={Lp} W={Wp}
R1 net3 net4 {Rval}
R2 net2 VDD {Rval}
M11 VDD VDD net1 net1 PMOS_CI2N L={Lp} W={Wp}
M12 VDD VDD net1 net1 PMOS_CI2N L={Lp} W={Wp}
R3 net4 VDD {Rval}
C1 VDD VDD {Cval}
R4 VDD net5 {Rval}
M13 net1 VDD 0 0 NMOS_CI2N L={Ln} W={Wn}
M14 VDD VDD 0 0 NMOS_CI2N L={Ln} W={Wn}
M15 VDD VDD 0 0 NMOS_CI2N L={Ln} W={Wn}
M16 VDD VDD 0 0 NMOS_CI2N L={Ln} W={Wn}
M17 VDD VDD 0 0 NMOS_CI2N L={Ln} W={Wn}
Q1 0 0 net5 PNP_CI2N
Q2 0 0 VDD PNP_CI2N
M18 VDD VDD 0 0 NMOS_CI2N L={Ln} W={Wn}
M19 VDD net6 0 0 NMOS_CI2N L={Ln} W={Wn}
* supply rails (added; not part of the CI2N netlist)
Vsup_VDD VDD 0 {VDD}
.op
.end
