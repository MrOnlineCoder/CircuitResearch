* CI2N circuit from experiments/04-hybrid-no-overlay/results/claude-sonnet-5.5-hybrid-no-overlay/golden/062.json
* ckt_type: DISO-Amplifier
* generated by ci2n_to_spice.py
* ---- placeholder values: CI2N netlists carry topology only; edit as needed ----
.param VDD=1.8 VSS=0
.param Rval=10k Cval=1p Ival=10u Vval=0.9
.param Wn=1u Ln=180n Wp=2u Lp=180n Aol=1e5
.model NMOS_CI2N NMOS (level=1 VTO=0.45 KP=200u LAMBDA=0.05)
.model PMOS_CI2N PMOS (level=1 VTO=-0.45 KP=80u LAMBDA=0.05)
.model NPN_CI2N NPN (Is=1e-16 Bf=100 Vaf=50)
.model PNP_CI2N PNP (Is=1e-16 Bf=50 Vaf=50)
.model D_CI2N D (Is=1e-14)

R1 net20 net8 {Rval}
R2 net17 net16 {Rval}
R3 net6 net12 {Rval}
I1 VDD net9 {Ival}
M1 net5 net6 VDD VDD PMOS_CI2N L={Lp} W={Wp}
M2 net1 net12 net19 net19 PMOS_CI2N L={Lp} W={Wp}
M3 net19 net6 VDD VDD PMOS_CI2N L={Lp} W={Wp}
M4 net20 net16 net18 net18 PMOS_CI2N L={Lp} W={Wp}
M5 net18 net17 VDD VDD PMOS_CI2N L={Lp} W={Wp}
M6 net17 net16 net14 net14 PMOS_CI2N L={Lp} W={Wp}
M7 net14 net17 VDD VDD PMOS_CI2N L={Lp} W={Wp}
M8 net6 net12 net13 net13 PMOS_CI2N L={Lp} W={Wp}
M9 net13 net6 VDD VDD PMOS_CI2N L={Lp} W={Wp}
M10 net16 net21 net10 net10 NMOS_CI2N L={Ln} W={Wn}
M11 net1 net20 net22 net22 NMOS_CI2N L={Ln} W={Wn}
M12 net3 net8 VSS VSS NMOS_CI2N L={Ln} W={Wn}
M13 net22 net8 VSS VSS NMOS_CI2N L={Ln} W={Wn}
M14 net23 net8 VSS VSS NMOS_CI2N L={Ln} W={Wn}
M15 net8 net20 net23 net23 NMOS_CI2N L={Ln} W={Wn}
M16 net12 net11 net10 net10 NMOS_CI2N L={Ln} W={Wn}
M17 net10 net9 VSS VSS NMOS_CI2N L={Ln} W={Wn}
M18 net9 net9 VSS VSS NMOS_CI2N L={Ln} W={Wn}
M19 VDD net5 net4 VSS1 NMOS_CI2N L={Ln} W={Wn}
M20 VDD net1 net3 VSS2 NMOS_CI2N L={Ln} W={Wn}
C1 net4 0 {Cval}
C2 net1 0 {Cval}
M21 VSS net3 net4 VDD1 PMOS_CI2N L={Lp} W={Wp}
M22 VSS net1 net5 VDD2 PMOS_CI2N L={Lp} W={Wp}
* supply rails (added; not part of the CI2N netlist)
Vsup_VDD VDD 0 {VDD}
Vsup_VSS VSS 0 {VSS}
Vsup_VSS1 VSS1 0 {VSS}
Vsup_VSS2 VSS2 0 {VSS}
Vsup_VDD1 VDD1 0 {VDD}
Vsup_VDD2 VDD2 0 {VDD}
.op
.end
