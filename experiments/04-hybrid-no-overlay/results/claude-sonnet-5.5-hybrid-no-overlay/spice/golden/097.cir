* CI2N circuit from experiments/04-hybrid-no-overlay/results/claude-sonnet-5.5-hybrid-no-overlay/golden/097.json
* ckt_type: DISO-Amplifier
* generated by ci2n_to_spice.py
* renamed nets: VIN\- -> VIN__n, VIN\+ -> VIN__p
* ---- placeholder values: CI2N netlists carry topology only; edit as needed ----
.param VDD=1.8 VSS=0
.param Rval=10k Cval=1p Ival=10u Vval=0.9
.param Wn=1u Ln=180n Wp=2u Lp=180n Aol=1e5
.model NMOS_CI2N NMOS (level=1 VTO=0.45 KP=200u LAMBDA=0.05)
.model PMOS_CI2N PMOS (level=1 VTO=-0.45 KP=80u LAMBDA=0.05)
.model NPN_CI2N NPN (Is=1e-16 Bf=100 Vaf=50)
.model PNP_CI2N PNP (Is=1e-16 Bf=50 Vaf=50)
.model D_CI2N D (Is=1e-14)

I1 VDD net14 {Ival}
I2 VDD net6 {Ival}
M1 net4 net16 VSS VSS NMOS_CI2N L={Ln} W={Wn}
M2 VDD net14 net16 net16 NMOS_CI2N L={Ln} W={Wn}
M3 net14 net14 net15 net15 NMOS_CI2N L={Ln} W={Wn}
M4 net13 VBN net12 net12 NMOS_CI2N L={Ln} W={Wn}
M5 net12 net6 VSS VSS NMOS_CI2N L={Ln} W={Wn}
M6 net11 VIN__n net10 net10 NMOS_CI2N L={Ln} W={Wn}
M7 net1 VIN__p net10 net10 NMOS_CI2N L={Ln} W={Wn}
M8 net10 net6 VSS VSS NMOS_CI2N L={Ln} W={Wn}
M9 net6 net6 VSS VSS NMOS_CI2N L={Ln} W={Wn}
M10 net4 net1 VDD VDD PMOS_CI2N L={Lp} W={Wp}
M11 VSS net13 net16 net16 PMOS_CI2N L={Lp} W={Wp}
M12 net13 net13 net15 net15 PMOS_CI2N L={Lp} W={Wp}
M13 net13 VBP net19 net19 PMOS_CI2N L={Lp} W={Wp}
M14 net19 net1 VDD VDD PMOS_CI2N L={Lp} W={Wp}
M15 net11 net11 VDD VDD PMOS_CI2N L={Lp} W={Wp}
M16 net1 net11 VDD VDD PMOS_CI2N L={Lp} W={Wp}
R1 net4 0 {Rval}
R2 net1 net17 {Rval}
C1 net4 0 {Cval}
C2 net17 net13 {Cval}
* supply rails (added; not part of the CI2N netlist)
Vsup_VDD VDD 0 {VDD}
Vsup_VSS VSS 0 {VSS}
.op
.end
