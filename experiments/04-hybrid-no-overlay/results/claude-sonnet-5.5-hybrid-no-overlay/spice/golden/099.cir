* CI2N circuit from experiments/04-hybrid-no-overlay/results/claude-sonnet-5.5-hybrid-no-overlay/golden/099.json
* ckt_type: Comparator
* generated by ci2n_to_spice.py
* renamed nets: CK$1 -> CK_1, CK$3 -> CK_3, CK$2 -> CK_2
* ---- placeholder values: CI2N netlists carry topology only; edit as needed ----
.param VDD=1.8 VSS=0
.param Rval=10k Cval=1p Ival=10u Vval=0.9
.param Wn=1u Ln=180n Wp=2u Lp=180n Aol=1e5
.model NMOS_CI2N NMOS (level=1 VTO=0.45 KP=200u LAMBDA=0.05)
.model PMOS_CI2N PMOS (level=1 VTO=-0.45 KP=80u LAMBDA=0.05)
.model NPN_CI2N NPN (Is=1e-16 Bf=100 Vaf=50)
.model PNP_CI2N PNP (Is=1e-16 Bf=50 Vaf=50)
.model D_CI2N D (Is=1e-14)

M1 VOUT2 VOUT1 net1 net1 NMOS_CI2N L={Ln} W={Wn}
M2 VOUT1 VOUT2 net2 net2 NMOS_CI2N L={Ln} W={Wn}
M3 net1 VIN2 net3 net3 NMOS_CI2N L={Ln} W={Wn}
M4 net2 VIN1 net3 net3 NMOS_CI2N L={Ln} W={Wn}
M5 net3 CK_1 0 0 NMOS_CI2N L={Ln} W={Wn}
M6 net1 CK_3 VDD VDD PMOS_CI2N L={Lp} W={Wp}
M7 VOUT2 CK_3 VDD VDD PMOS_CI2N L={Lp} W={Wp}
M8 net2 CK_2 VDD VDD PMOS_CI2N L={Lp} W={Wp}
M9 VOUT1 CK_2 VDD VDD PMOS_CI2N L={Lp} W={Wp}
M10 VOUT1 VOUT2 VDD VDD PMOS_CI2N L={Lp} W={Wp}
M11 VOUT2 VOUT1 VDD VDD PMOS_CI2N L={Lp} W={Wp}
* supply rails (added; not part of the CI2N netlist)
Vsup_VDD VDD 0 {VDD}
.op
.end
