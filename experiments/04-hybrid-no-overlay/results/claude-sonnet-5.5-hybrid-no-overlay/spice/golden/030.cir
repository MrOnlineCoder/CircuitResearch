* CI2N circuit from experiments/04-hybrid-no-overlay/results/claude-sonnet-5.5-hybrid-no-overlay/golden/030.json
* ckt_type: DISO-Amplifier
* generated by ci2n_to_spice.py
* renamed nets: vdd! -> vdd_, VIN\+ -> VIN__p, VIN\- -> VIN__n
* ---- placeholder values: CI2N netlists carry topology only; edit as needed ----
.param VDD=1.8 VSS=0
.param Rval=10k Cval=1p Ival=10u Vval=0.9
.param Wn=1u Ln=180n Wp=2u Lp=180n Aol=1e5
.model NMOS_CI2N NMOS (level=1 VTO=0.45 KP=200u LAMBDA=0.05)
.model PMOS_CI2N PMOS (level=1 VTO=-0.45 KP=80u LAMBDA=0.05)
.model NPN_CI2N NPN (Is=1e-16 Bf=100 Vaf=50)
.model PNP_CI2N PNP (Is=1e-16 Bf=50 Vaf=50)
.model D_CI2N D (Is=1e-14)

M1 VOUT net4 vdd_ vdd_ PMOS_CI2N L={Lp} W={Wp}
M2 net4 net4 vdd_ vdd_ PMOS_CI2N L={Lp} W={Wp}
M3 net4 net3 vdd_ vdd_ PMOS_CI2N L={Lp} W={Wp}
M4 net3 net4 vdd_ vdd_ PMOS_CI2N L={Lp} W={Wp}
M5 net3 net3 vdd_ vdd_ PMOS_CI2N L={Lp} W={Wp}
M6 net1 net3 vdd_ vdd_ PMOS_CI2N L={Lp} W={Wp}
M7 VOUT net1 0 0 NMOS_CI2N L={Ln} W={Wn}
M8 net1 net1 0 0 NMOS_CI2N L={Ln} W={Wn}
M9 net3 VIN__p net5 net5 NMOS_CI2N L={Ln} W={Wn}
M10 net4 VIN__n net5 net5 NMOS_CI2N L={Ln} W={Wn}
I1 net5 0 {Ival}
* supply rails (added; not part of the CI2N netlist)
Vsup_vdd_ vdd_ 0 {VDD}
.op
.end
