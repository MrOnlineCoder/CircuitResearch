* CI2N circuit from experiments/04-hybrid-no-overlay/results/claude-sonnet-5.5-hybrid-no-overlay/golden/051.json
* ckt_type: DISO-Amplifier
* generated by ci2n_to_spice.py
* renamed nets: Vbp$1 -> Vbp_1, Vbn$1 -> Vbn_1
* ---- placeholder values: CI2N netlists carry topology only; edit as needed ----
.param VDD=1.8 VSS=0
.param Rval=10k Cval=1p Ival=10u Vval=0.9
.param Wn=1u Ln=180n Wp=2u Lp=180n Aol=1e5
.model NMOS_CI2N NMOS (level=1 VTO=0.45 KP=200u LAMBDA=0.05)
.model PMOS_CI2N PMOS (level=1 VTO=-0.45 KP=80u LAMBDA=0.05)
.model NPN_CI2N NPN (Is=1e-16 Bf=100 Vaf=50)
.model PNP_CI2N PNP (Is=1e-16 Bf=50 Vaf=50)
.model D_CI2N D (Is=1e-14)

M1 net1 net21 VDD_x VDD_x PMOS_CI2N L={Lp} W={Wp}
M2 net18 net21 net19 net19 PMOS_CI2N L={Lp} W={Wp}
M3 net2 net18 net9 net9 PMOS_CI2N L={Lp} W={Wp}
M4 net21 net17 net9 net9 PMOS_CI2N L={Lp} W={Wp}
M5 net8 Vip net12 net12 PMOS_CI2N L={Lp} W={Wp}
M6 net7 Vin net12 net12 PMOS_CI2N L={Lp} W={Wp}
M7 net6 net17 net14 net14 PMOS_CI2N L={Lp} W={Wp}
M8 net16 net16 VDD_x VDD_x PMOS_CI2N L={Lp} W={Wp}
M9 net20 net20 VDD_x VDD_x PMOS_CI2N L={Lp} W={Wp}
M10 net19 Vbp VDD_x VDD_x PMOS_CI2N L={Lp} W={Wp}
M11 net9 net6 VDD_x VDD_x PMOS_CI2N L={Lp} W={Wp}
M12 net14 net6 VDD_x VDD_x PMOS_CI2N L={Lp} W={Wp}
M13 net12 Vbp_1 VDD_x VDD_x PMOS_CI2N L={Lp} W={Wp}
M14 net1 net2 0 0 NMOS_CI2N L={Ln} W={Wn}
M15 net3 net2 net4 net4 NMOS_CI2N L={Ln} W={Wn}
M16 net4 Vbn_1 0 0 NMOS_CI2N L={Ln} W={Wn}
M17 net11 net11 0 0 NMOS_CI2N L={Ln} W={Wn}
M18 net8 Vbn 0 0 NMOS_CI2N L={Ln} W={Wn}
M19 net7 Vbn 0 0 NMOS_CI2N L={Ln} W={Wn}
M20 net10 net10 0 0 NMOS_CI2N L={Ln} W={Wn}
M21 net2 net5 net8 net8 NMOS_CI2N L={Ln} W={Wn}
M22 net21 net3 net8 net8 NMOS_CI2N L={Ln} W={Wn}
M23 net6 net5 net7 net7 NMOS_CI2N L={Ln} W={Wn}
R1 net20 net18 {Rval}
R2 net3 net11 {Rval}
R3 net5 net10 {Rval}
R4 net16 net17 {Rval}
I1 VDD net3 {Ival}
I2 VDD net5 {Ival}
I3 net17 0 {Ival}
I4 net18 0 {Ival}
* supply rails (added; not part of the CI2N netlist)
Vsup_VDD_x VDD_x 0 {VDD}
Vsup_VDD VDD 0 {VDD}
.op
.end
