* CI2N circuit from experiments/04-hybrid-no-overlay/results/claude-sonnet-5.5-hybrid-no-overlay/golden/104.json
* ckt_type: DIDO-Amplifier
* generated by ci2n_to_spice.py
* renamed nets: VOUT\+ -> VOUT__p, VOUT\- -> VOUT__n, VIN+ -> VIN_p, VIN- -> VIN_n
* ---- placeholder values: CI2N netlists carry topology only; edit as needed ----
.param VDD=1.8 VSS=0
.param Rval=10k Cval=1p Ival=10u Vval=0.9
.param Wn=1u Ln=180n Wp=2u Lp=180n Aol=1e5
.model NMOS_CI2N NMOS (level=1 VTO=0.45 KP=200u LAMBDA=0.05)
.model PMOS_CI2N PMOS (level=1 VTO=-0.45 KP=80u LAMBDA=0.05)
.model NPN_CI2N NPN (Is=1e-16 Bf=100 Vaf=50)
.model PNP_CI2N PNP (Is=1e-16 Bf=50 Vaf=50)
.model D_CI2N D (Is=1e-14)

.subckt DIDO_AMP inp inn outp outn
E1 outp 0 inp inn {Aol/2}
E2 outn 0 inn inp {Aol/2}
.ends DIDO_AMP

M1 VOUT__p V4 net10 net10 NMOS_CI2N L={Ln} W={Wn}
M2 VOUT__n V4 net1 net1 NMOS_CI2N L={Ln} W={Wn}
M3 net8 VCMFB 0 0 NMOS_CI2N L={Ln} W={Wn}
M4 net11 VCMFB 0 0 NMOS_CI2N L={Ln} W={Wn}
M5 net10 net13 net11 net11 NMOS_CI2N L={Ln} W={Wn}
M6 net1 net12 net8 net8 NMOS_CI2N L={Ln} W={Wn}
M7 net3 V1 0 0 NMOS_CI2N L={Ln} W={Wn}
M8 net5 V2 net3 net3 NMOS_CI2N L={Ln} W={Wn}
M9 net4 VIN_p net5 net5 NMOS_CI2N L={Ln} W={Wn}
M10 net16 VIN_n net5 net5 NMOS_CI2N L={Ln} W={Wn}
M11 VOUT__p net15 net16 net16 PMOS_CI2N L={Lp} W={Wp}
M12 VOUT__n net14 net4 net4 PMOS_CI2N L={Lp} W={Wp}
M13 net16 V3 VDD VDD PMOS_CI2N L={Lp} W={Wp}
M14 net4 V3 VDD VDD PMOS_CI2N L={Lp} W={Wp}
X1 net8 net11 net13 net12 DIDO_AMP
X2 net4 net16 net15 net14 DIDO_AMP
* supply rails (added; not part of the CI2N netlist)
Vsup_VDD VDD 0 {VDD}
.op
.end
