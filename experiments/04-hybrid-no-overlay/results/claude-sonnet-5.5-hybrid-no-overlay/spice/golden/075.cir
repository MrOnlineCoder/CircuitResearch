* CI2N circuit from experiments/04-hybrid-no-overlay/results/claude-sonnet-5.5-hybrid-no-overlay/golden/075.json
* ckt_type: DISO-Amplifier
* generated by ci2n_to_spice.py
* ---- placeholder values: CI2N netlists carry topology only; edit as needed ----
.param VDD=1.8 VSS=0
.param Rval=10k Cval=1p Ival=10u Vval=0.9
.param Wn=1u Ln=180n Wp=2u Lp=180n Aol=1e5
.model NMOS_CI2N NMOS (level=1 VTO=0.45 KP=200u LAMBDA=0.05)
.model PMOS_CI2N PMOS (level=1 VTO=-0.45 KP=80u LAMBDA=0.05)
.model NPN_CI2N NPN (Is=1e-16 Bf=100 Vaf=50)
.model PNP_CI2N PNP (Is=1e-16 Bf=50 Vaf=50)
.model D_CI2N D (Is=1e-14)

C1 net38 0 {Cval}
C2 net38 net33 {Cval}
R1 net5 VSS {Rval}
M1 net42 net31 VDD VDD PMOS_CI2N L={Lp} W={Wp}
M2 net31 net31 VDD VDD PMOS_CI2N L={Lp} W={Wp}
M3 net23 vin net21 net21 NMOS_CI2N L={Ln} W={Wn}
M4 net42 vip net21 net21 NMOS_CI2N L={Ln} W={Wn}
M5 net42 net23 VDD VDD PMOS_CI2N L={Lp} W={Wp}
M6 net23 net23 VDD VDD PMOS_CI2N L={Lp} W={Wp}
M7 net11 net11 net12 net12 PMOS_CI2N L={Lp} W={Wp}
M8 net20 net11 net15 net15 PMOS_CI2N L={Lp} W={Wp}
M9 net15 net12 VDD VDD PMOS_CI2N L={Lp} W={Wp}
M10 net12 net12 VDD VDD PMOS_CI2N L={Lp} W={Wp}
M11 net38 net20 VSS VSS NMOS_CI2N L={Ln} W={Wn}
M12 net33 net20 VSS VSS NMOS_CI2N L={Ln} W={Wn}
M13 net27 net20 VSS VSS NMOS_CI2N L={Ln} W={Wn}
M14 net21 net20 VSS VSS NMOS_CI2N L={Ln} W={Wn}
M15 net38 net42 VDD VDD PMOS_CI2N L={Lp} W={Wp}
M16 net42 0 net33 net33 NMOS_CI2N L={Ln} W={Wn}
M17 net31 0 net27 net27 NMOS_CI2N L={Ln} W={Wn}
M18 net20 net20 VSS VSS NMOS_CI2N L={Ln} W={Wn}
M19 net11 net20 net5 net5 NMOS_CI2N L={Ln} W={Wn}
* supply rails (added; not part of the CI2N netlist)
Vsup_VSS VSS 0 {VSS}
Vsup_VDD VDD 0 {VDD}
.op
.end
