* CI2N circuit from experiments/04-hybrid-no-overlay/results/claude-sonnet-5.5-hybrid-no-overlay/golden/092.json
* ckt_type: DIDO-Amplifier
* generated by ci2n_to_spice.py
* renamed nets: Vout- -> Vout_n, Vout+ -> Vout_p, Vin- -> Vin_n, Vin+ -> Vin_p
* ---- placeholder values: CI2N netlists carry topology only; edit as needed ----
.param VDD=1.8 VSS=0
.param Rval=10k Cval=1p Ival=10u Vval=0.9
.param Wn=1u Ln=180n Wp=2u Lp=180n Aol=1e5
.model NMOS_CI2N NMOS (level=1 VTO=0.45 KP=200u LAMBDA=0.05)
.model PMOS_CI2N PMOS (level=1 VTO=-0.45 KP=80u LAMBDA=0.05)
.model NPN_CI2N NPN (Is=1e-16 Bf=100 Vaf=50)
.model PNP_CI2N PNP (Is=1e-16 Bf=50 Vaf=50)
.model D_CI2N D (Is=1e-14)

.subckt DIDO_AMP inp inn outp outn
E1 outp 0 inp inn {Aol/2}
E2 outn 0 inn inp {Aol/2}
.ends DIDO_AMP

X1 net13 net11 net19 net14 DIDO_AMP
X2 net7 net18 net17 net15 DIDO_AMP
M1 Vout_n net15 net7 net7 PMOS_CI2N L={Lp} W={Wp}
M2 Vout_p net17 net18 net18 PMOS_CI2N L={Lp} W={Wp}
M3 net18 net22 VDD VDD PMOS_CI2N L={Lp} W={Wp}
M4 net7 net22 VDD VDD PMOS_CI2N L={Lp} W={Wp}
M5 net9 VCMFB 0 0 NMOS_CI2N L={Ln} W={Wn}
M6 net11 Vin_n net9 net9 NMOS_CI2N L={Ln} W={Wn}
M7 net13 Vin_p net9 net9 NMOS_CI2N L={Ln} W={Wn}
M8 Vout_p net19 net11 net11 NMOS_CI2N L={Ln} W={Wn}
M9 Vout_n net14 net13 net13 NMOS_CI2N L={Ln} W={Wn}
* supply rails (added; not part of the CI2N netlist)
Vsup_VDD VDD 0 {VDD}
.op
.end
