* CI2N circuit from experiments/04-hybrid-no-overlay/results/claude-sonnet-5.5-hybrid-no-overlay/golden/073.json
* ckt_type: DIDO-Amplifier
* generated by ci2n_to_spice.py
* renamed nets: vcascp$1 -> vcascp_1, vbm$1 -> vbm_1, vbp$1 -> vbp_1
* ---- placeholder values: CI2N netlists carry topology only; edit as needed ----
.param VDD=1.8 VSS=0
.param Rval=10k Cval=1p Ival=10u Vval=0.9
.param Wn=1u Ln=180n Wp=2u Lp=180n Aol=1e5
.model NMOS_CI2N NMOS (level=1 VTO=0.45 KP=200u LAMBDA=0.05)
.model PMOS_CI2N PMOS (level=1 VTO=-0.45 KP=80u LAMBDA=0.05)
.model NPN_CI2N NPN (Is=1e-16 Bf=100 Vaf=50)
.model PNP_CI2N PNP (Is=1e-16 Bf=50 Vaf=50)
.model D_CI2N D (Is=1e-14)

M1 net55 vcascp net45 net45 PMOS_CI2N L={Lp} W={Wp}
M2 net41 vinn net36 net36 PMOS_CI2N L={Lp} W={Wp}
M3 net60 vinp net36 net36 PMOS_CI2N L={Lp} W={Wp}
M4 net51 net51 VDD VDD PMOS_CI2N L={Lp} W={Wp}
M5 net55 net51 VDD VDD PMOS_CI2N L={Lp} W={Wp}
M6 net45 vbm VDD VDD PMOS_CI2N L={Lp} W={Wp}
M7 net36 vtail VDD VDD PMOS_CI2N L={Lp} W={Wp}
M8 net25 vcascp_1 net32 net32 PMOS_CI2N L={Lp} W={Wp}
M9 net32 vbm_1 VDD VDD PMOS_CI2N L={Lp} W={Wp}
M10 net23 net23 VDD VDD PMOS_CI2N L={Lp} W={Wp}
M11 net25 net23 VDD VDD PMOS_CI2N L={Lp} W={Wp}
C1 net55 0 {Cval}
C2 net25 0 {Cval}
M12 net51 net41 0 0 NMOS_CI2N L={Ln} W={Wn}
M13 net25 net41 0 0 NMOS_CI2N L={Ln} W={Wn}
M14 net41 net41 0 0 NMOS_CI2N L={Ln} W={Wn}
M15 net55 vbp net41 net41 NMOS_CI2N L={Ln} W={Wn}
M16 net60 net60 0 0 NMOS_CI2N L={Ln} W={Wn}
M17 net60 vcmfb 0 0 NMOS_CI2N L={Ln} W={Wn}
M18 net41 vcmfb 0 0 NMOS_CI2N L={Ln} W={Wn}
M19 net25 vbp_1 net60 net60 NMOS_CI2N L={Ln} W={Wn}
M20 net55 net60 0 0 NMOS_CI2N L={Ln} W={Wn}
M21 net23 net60 0 0 NMOS_CI2N L={Ln} W={Wn}
* supply rails (added; not part of the CI2N netlist)
Vsup_VDD VDD 0 {VDD}
.op
.end
