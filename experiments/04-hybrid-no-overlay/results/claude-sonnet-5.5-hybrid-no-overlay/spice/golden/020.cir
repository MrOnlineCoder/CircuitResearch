* CI2N circuit from experiments/04-hybrid-no-overlay/results/claude-sonnet-5.5-hybrid-no-overlay/golden/020.json
* ckt_type: DIDO-Amplifier
* generated by ci2n_to_spice.py
* ---- placeholder values: CI2N netlists carry topology only; edit as needed ----
.param VDD=1.8 VSS=0
.param Rval=10k Cval=1p Ival=10u Vval=0.9
.param Wn=1u Ln=180n Wp=2u Lp=180n Aol=1e5
.model NMOS_CI2N NMOS (level=1 VTO=0.45 KP=200u LAMBDA=0.05)
.model PMOS_CI2N PMOS (level=1 VTO=-0.45 KP=80u LAMBDA=0.05)
.model NPN_CI2N NPN (Is=1e-16 Bf=100 Vaf=50)
.model PNP_CI2N PNP (Is=1e-16 Bf=50 Vaf=50)
.model D_CI2N D (Is=1e-14)

M1 net11 net1 0 0 NMOS_CI2N L={Ln} W={Wn}
M2 net10 net6 0 0 NMOS_CI2N L={Ln} W={Wn}
M3 net7 net9 0 0 NMOS_CI2N L={Ln} W={Wn}
M4 net6 net8 net7 net7 NMOS_CI2N L={Ln} W={Wn}
M5 net2 net5 0 0 NMOS_CI2N L={Ln} W={Wn}
M6 net1 net3 net2 net2 NMOS_CI2N L={Ln} W={Wn}
M7 net27 0 net6 net6 PMOS_CI2N L={Lp} W={Wp}
M8 net26 0 net1 net1 PMOS_CI2N L={Lp} W={Wp}
M9 net10 net25 net12 net12 PMOS_CI2N L={Lp} W={Wp}
M10 net22 net24 net12 net12 PMOS_CI2N L={Lp} W={Wp}
M11 net6 net23 net22 net22 PMOS_CI2N L={Lp} W={Wp}
M12 net7 net21 net17 net17 PMOS_CI2N L={Lp} W={Wp}
M13 net17 net20 net12 net12 PMOS_CI2N L={Lp} W={Wp}
M14 net2 net18 net17 net17 PMOS_CI2N L={Lp} W={Wp}
M15 net14 net16 net12 net12 PMOS_CI2N L={Lp} W={Wp}
M16 net1 net15 net14 net14 PMOS_CI2N L={Lp} W={Wp}
M17 net11 net13 net12 net12 PMOS_CI2N L={Lp} W={Wp}
C1 net27 net10 {Cval}
C2 net11 net26 {Cval}
.op
.end
