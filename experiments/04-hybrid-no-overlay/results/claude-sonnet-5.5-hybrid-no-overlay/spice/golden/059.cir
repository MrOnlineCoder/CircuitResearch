* CI2N circuit from experiments/04-hybrid-no-overlay/results/claude-sonnet-5.5-hybrid-no-overlay/golden/059.json
* ckt_type: DISO-Amplifier
* generated by ci2n_to_spice.py
* renamed nets: Vi- -> Vi_n, Vi+ -> Vi_p
* ---- placeholder values: CI2N netlists carry topology only; edit as needed ----
.param VDD=1.8 VSS=0
.param Rval=10k Cval=1p Ival=10u Vval=0.9
.param Wn=1u Ln=180n Wp=2u Lp=180n Aol=1e5
.model NMOS_CI2N NMOS (level=1 VTO=0.45 KP=200u LAMBDA=0.05)
.model PMOS_CI2N PMOS (level=1 VTO=-0.45 KP=80u LAMBDA=0.05)
.model NPN_CI2N NPN (Is=1e-16 Bf=100 Vaf=50)
.model PNP_CI2N PNP (Is=1e-16 Bf=50 Vaf=50)
.model D_CI2N D (Is=1e-14)

M1 Vo net2 VDD VDD PMOS_CI2N L={Lp} W={Wp}
M2 net2 net1 VDD VDD PMOS_CI2N L={Lp} W={Wp}
M3 net1 net1 VDD VDD PMOS_CI2N L={Lp} W={Wp}
M4 Vo VBIAS VSS VSS NMOS_CI2N L={Ln} W={Wn}
M5 net3 VBIAS VSS VSS NMOS_CI2N L={Ln} W={Wn}
M6 net2 Vi_n net3 net3 NMOS_CI2N L={Ln} W={Wn}
M7 net1 Vi_p net3 net3 NMOS_CI2N L={Ln} W={Wn}
C1 net2 net4 {Cval}
R1 net4 Vo {Rval}
* supply rails (added; not part of the CI2N netlist)
Vsup_VDD VDD 0 {VDD}
Vsup_VSS VSS 0 {VSS}
.op
.end
