* CI2N circuit from experiments/04-hybrid-no-overlay/results/claude-sonnet-5.5-hybrid-no-overlay/golden/024.json
* ckt_type: Bandgap
* generated by ci2n_to_spice.py
* renamed nets: vdd! -> vdd_
* ---- placeholder values: CI2N netlists carry topology only; edit as needed ----
.param VDD=1.8 VSS=0
.param Rval=10k Cval=1p Ival=10u Vval=0.9
.param Wn=1u Ln=180n Wp=2u Lp=180n Aol=1e5
.model NMOS_CI2N NMOS (level=1 VTO=0.45 KP=200u LAMBDA=0.05)
.model PMOS_CI2N PMOS (level=1 VTO=-0.45 KP=80u LAMBDA=0.05)
.model NPN_CI2N NPN (Is=1e-16 Bf=100 Vaf=50)
.model PNP_CI2N PNP (Is=1e-16 Bf=50 Vaf=50)
.model D_CI2N D (Is=1e-14)

M1 net1 net10 0 0 NMOS_CI2N L={Ln} W={Wn}
M2 net9 net10 0 0 NMOS_CI2N L={Ln} W={Wn}
M3 net10 net8 0 0 NMOS_CI2N L={Ln} W={Wn}
M4 net9 net8 0 0 NMOS_CI2N L={Ln} W={Wn}
M5 net8 net8 0 0 NMOS_CI2N L={Ln} W={Wn}
M6 net7 net7 0 0 NMOS_CI2N L={Ln} W={Wn}
M7 net6 net7 0 0 NMOS_CI2N L={Ln} W={Wn}
M8 net5 net5 0 0 NMOS_CI2N L={Ln} W={Wn}
M9 net3 net5 0 0 NMOS_CI2N L={Ln} W={Wn}
M10 net1 net3 0 0 NMOS_CI2N L={Ln} W={Wn}
M11 net36 net9 net33 net33 PMOS_CI2N L={Lp} W={Wp}
M12 net33 net1 vdd_ vdd_ PMOS_CI2N L={Lp} W={Wp}
M13 net29 net1 vdd_ vdd_ PMOS_CI2N L={Lp} W={Wp}
M14 net28 net9 net29 net29 PMOS_CI2N L={Lp} W={Wp}
M15 net25 net9 net23 net23 PMOS_CI2N L={Lp} W={Wp}
M16 net23 net1 vdd_ vdd_ PMOS_CI2N L={Lp} W={Wp}
M17 net1 net6 vdd_ vdd_ PMOS_CI2N L={Lp} W={Wp}
M18 net18 net6 vdd_ vdd_ PMOS_CI2N L={Lp} W={Wp}
M19 net3 net21 net18 net18 PMOS_CI2N L={Lp} W={Wp}
M20 net5 net19 net18 net18 PMOS_CI2N L={Lp} W={Wp}
M21 net6 net6 vdd_ vdd_ PMOS_CI2N L={Lp} W={Wp}
M22 net7 net9 net16 net16 PMOS_CI2N L={Lp} W={Wp}
M23 net16 net1 vdd_ vdd_ PMOS_CI2N L={Lp} W={Wp}
M24 net15 net1 vdd_ vdd_ PMOS_CI2N L={Lp} W={Wp}
M25 net8 net9 net15 net15 PMOS_CI2N L={Lp} W={Wp}
M26 net9 net9 vdd_ vdd_ PMOS_CI2N L={Lp} W={Wp}
M27 net13 0 vdd_ vdd_ PMOS_CI2N L={Lp} W={Wp}
M28 net10 0 net13 net13 PMOS_CI2N L={Lp} W={Wp}
R1 net3 net4 {Rval}
R2 net25 net21 {Rval}
R3 net21 0 {Rval}
R4 net25 net2 {Rval}
R5 net19 0 {Rval}
R6 net28 net19 {Rval}
R7 net36 0 {Rval}
C1 net4 net1 {Cval}
Q1 0 0 net2 PNP_CI2N
Q2 0 0 net28 PNP_CI2N
* supply rails (added; not part of the CI2N netlist)
Vsup_vdd_ vdd_ 0 {VDD}
.op
.end
