* CI2N circuit from experiments/04-hybrid-no-overlay/results/claude-sonnet-5.5-hybrid-no-overlay/golden/049.json
* ckt_type: DISO-Amplifier
* generated by ci2n_to_spice.py
* ---- placeholder values: CI2N netlists carry topology only; edit as needed ----
.param VDD=1.8 VSS=0
.param Rval=10k Cval=1p Ival=10u Vval=0.9
.param Wn=1u Ln=180n Wp=2u Lp=180n Aol=1e5
.model NMOS_CI2N NMOS (level=1 VTO=0.45 KP=200u LAMBDA=0.05)
.model PMOS_CI2N PMOS (level=1 VTO=-0.45 KP=80u LAMBDA=0.05)
.model NPN_CI2N NPN (Is=1e-16 Bf=100 Vaf=50)
.model PNP_CI2N PNP (Is=1e-16 Bf=50 Vaf=50)
.model D_CI2N D (Is=1e-14)

M1 net6 net2 0 0 NMOS_CI2N L={Ln} W={Wn}
M2 net1 net5 0 0 NMOS_CI2N L={Ln} W={Wn}
M3 net5 net5 0 0 NMOS_CI2N L={Ln} W={Wn}
M4 net2 net2 0 0 NMOS_CI2N L={Ln} W={Wn}
I1 AVDD net3 {Ival}
R1 VOUT 0 {Rval}
M5 net1 net1 AVDD AVDD PMOS_CI2N L={Lp} W={Wp}
M6 net6 net1 AVDD AVDD PMOS_CI2N L={Lp} W={Wp}
M7 VOUT net6 AVDD AVDD PMOS_CI2N L={Lp} W={Wp}
M8 net4 enb net3 net3 PMOS_CI2N L={Lp} W={Wp}
M9 net5 vp net4 net4 PMOS_CI2N L={Lp} W={Wp}
M10 net2 vn net4 net4 PMOS_CI2N L={Lp} W={Wp}
* supply rails (added; not part of the CI2N netlist)
Vsup_AVDD AVDD 0 {VDD}
.op
.end
