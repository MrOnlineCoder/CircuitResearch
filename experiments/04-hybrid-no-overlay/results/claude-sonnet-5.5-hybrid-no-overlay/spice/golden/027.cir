* CI2N circuit from experiments/04-hybrid-no-overlay/results/claude-sonnet-5.5-hybrid-no-overlay/golden/027.json
* ckt_type: Bandgap
* generated by ci2n_to_spice.py
* ---- placeholder values: CI2N netlists carry topology only; edit as needed ----
.param VDD=1.8 VSS=0
.param Rval=10k Cval=1p Ival=10u Vval=0.9
.param Wn=1u Ln=180n Wp=2u Lp=180n Aol=1e5
.model NMOS_CI2N NMOS (level=1 VTO=0.45 KP=200u LAMBDA=0.05)
.model PMOS_CI2N PMOS (level=1 VTO=-0.45 KP=80u LAMBDA=0.05)
.model NPN_CI2N NPN (Is=1e-16 Bf=100 Vaf=50)
.model PNP_CI2N PNP (Is=1e-16 Bf=50 Vaf=50)
.model D_CI2N D (Is=1e-14)

M1 net3 net1 0 0 NMOS_CI2N L={Ln} W={Wn}
M2 net16 net1 0 0 NMOS_CI2N L={Ln} W={Wn}
M3 net14 net1 0 0 NMOS_CI2N L={Ln} W={Wn}
M4 sink net2 net3 net3 NMOS_CI2N L={Ln} W={Wn}
M5 net1 net2 net16 net16 NMOS_CI2N L={Ln} W={Wn}
M6 net15 net2 net14 net14 NMOS_CI2N L={Ln} W={Wn}
M7 net7 net8 net5 net5 NMOS_CI2N L={Ln} W={Wn}
M8 net8 net8 0 0 NMOS_CI2N L={Ln} W={Wn}
R1 net2 net1 {Rval}
R2 net5 0 {Rval}
M9 net12 net7 net10 net10 PMOS_CI2N L={Lp} W={Wp}
M10 net11 net7 net10 net10 PMOS_CI2N L={Lp} W={Wp}
M11 source net15 net12 net12 PMOS_CI2N L={Lp} W={Wp}
M12 net2 net15 net11 net11 PMOS_CI2N L={Lp} W={Wp}
M13 net15 net15 net10 net10 PMOS_CI2N L={Lp} W={Wp}
M14 net6 net7 net10 net10 PMOS_CI2N L={Lp} W={Wp}
M15 net9 net7 net10 net10 PMOS_CI2N L={Lp} W={Wp}
M16 net7 net15 net6 net6 PMOS_CI2N L={Lp} W={Wp}
M17 net8 net15 net9 net9 PMOS_CI2N L={Lp} W={Wp}
.op
.end
