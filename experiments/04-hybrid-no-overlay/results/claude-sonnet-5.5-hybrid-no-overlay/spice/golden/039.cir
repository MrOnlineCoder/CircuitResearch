* CI2N circuit from experiments/04-hybrid-no-overlay/results/claude-sonnet-5.5-hybrid-no-overlay/golden/039.json
* ckt_type: Bandgap
* generated by ci2n_to_spice.py
* ---- placeholder values: CI2N netlists carry topology only; edit as needed ----
.param VDD=1.8 VSS=0
.param Rval=10k Cval=1p Ival=10u Vval=0.9
.param Wn=1u Ln=180n Wp=2u Lp=180n Aol=1e5
.model NMOS_CI2N NMOS (level=1 VTO=0.45 KP=200u LAMBDA=0.05)
.model PMOS_CI2N PMOS (level=1 VTO=-0.45 KP=80u LAMBDA=0.05)
.model NPN_CI2N NPN (Is=1e-16 Bf=100 Vaf=50)
.model PNP_CI2N PNP (Is=1e-16 Bf=50 Vaf=50)
.model D_CI2N D (Is=1e-14)

M1 net8 net7 VDD VDD PMOS_CI2N L={Lp} W={Wp}
M2 net8 net14 VDD VDD PMOS_CI2N L={Lp} W={Wp}
M3 net5 net14 VDD VDD PMOS_CI2N L={Lp} W={Wp}
M4 net9 net9 VDD VDD PMOS_CI2N L={Lp} W={Wp}
M5 net3 net5 net2 net2 PMOS_CI2N L={Lp} W={Wp}
M6 net4 net6 net2 net2 PMOS_CI2N L={Lp} W={Wp}
M7 net1 net1 VDD VDD PMOS_CI2N L={Lp} W={Wp}
M8 net7 net1 VDD VDD PMOS_CI2N L={Lp} W={Wp}
M9 net2 net9 VDD VDD PMOS_CI2N L={Lp} W={Wp}
M10 net11 net7 VDD VDD PMOS_CI2N L={Lp} W={Wp}
M11 net14 net7 VDD VDD PMOS_CI2N L={Lp} W={Wp}
M12 net13 net7 VDD VDD PMOS_CI2N L={Lp} W={Wp}
R1 net6 net15 {Rval}
R2 net11 net12 {Rval}
R3 net12 net5 {Rval}
R4 net13 net6 {Rval}
Q1 0 0 net5 PNP_CI2N
Q2 0 0 net15 PNP_CI2N
M13 net1 net3 0 0 NMOS_CI2N L={Ln} W={Wn}
M14 net3 net3 0 0 NMOS_CI2N L={Ln} W={Wn}
M15 net4 net4 0 0 NMOS_CI2N L={Ln} W={Wn}
M16 net7 net4 0 0 NMOS_CI2N L={Ln} W={Wn}
M17 net9 net8 0 0 NMOS_CI2N L={Ln} W={Wn}
M18 net8 net8 0 0 NMOS_CI2N L={Ln} W={Wn}
M19 net14 VDD1 0 0 NMOS_CI2N L={Ln} W={Wn}
C1 net7 net6 {Cval}
* supply rails (added; not part of the CI2N netlist)
Vsup_VDD VDD 0 {VDD}
Vsup_VDD1 VDD1 0 {VDD}
.op
.end
