* CI2N circuit from experiments/04-hybrid-no-overlay/results/claude-sonnet-5.5-hybrid-no-overlay/golden/007.json
* ckt_type: Bandgap
* generated by ci2n_to_spice.py
* ---- placeholder values: CI2N netlists carry topology only; edit as needed ----
.param VDD=1.8 VSS=0
.param Rval=10k Cval=1p Ival=10u Vval=0.9
.param Wn=1u Ln=180n Wp=2u Lp=180n Aol=1e5
.model NMOS_CI2N NMOS (level=1 VTO=0.45 KP=200u LAMBDA=0.05)
.model PMOS_CI2N PMOS (level=1 VTO=-0.45 KP=80u LAMBDA=0.05)
.model NPN_CI2N NPN (Is=1e-16 Bf=100 Vaf=50)
.model PNP_CI2N PNP (Is=1e-16 Bf=50 Vaf=50)
.model D_CI2N D (Is=1e-14)

M1 net15 net17 net10 net10 PMOS_CI2N L={Lp} W={Wp}
M2 net16 net1 net10 net10 PMOS_CI2N L={Lp} W={Wp}
M3 net9 net9 VDD VDD PMOS_CI2N L={Lp} W={Wp}
M4 net4 net9 net2 net2 PMOS_CI2N L={Lp} W={Wp}
M5 PLUS net9 net8 net8 PMOS_CI2N L={Lp} W={Wp}
M6 net17 net9 net7 net7 PMOS_CI2N L={Lp} W={Wp}
M7 net10 net9 net6 net6 PMOS_CI2N L={Lp} W={Wp}
M8 net1 net9 net5 net5 PMOS_CI2N L={Lp} W={Wp}
M9 net8 net4 VDD VDD PMOS_CI2N L={Lp} W={Wp}
M10 net7 net4 VDD VDD PMOS_CI2N L={Lp} W={Wp}
M11 net6 net4 VDD VDD PMOS_CI2N L={Lp} W={Wp}
M12 net5 net4 VDD VDD PMOS_CI2N L={Lp} W={Wp}
M13 net2 net4 VDD VDD PMOS_CI2N L={Lp} W={Wp}
M14 net15 net16 0 0 NMOS_CI2N L={Ln} W={Wn}
M15 net16 net16 0 0 NMOS_CI2N L={Ln} W={Wn}
M16 0 net15 0 0 NMOS_CI2N L={Ln} W={Wn}
M17 net4 net15 0 0 NMOS_CI2N L={Ln} W={Wn}
M18 net9 net15 0 0 NMOS_CI2N L={Ln} W={Wn}
R1 PLUS 0 {Rval}
R2 net17 net11 {Rval}
R3 net17 0 {Rval}
R4 net1 0 {Rval}
Q1 0 0 net11 PNP_CI2N
Q2 0 0 net1 PNP_CI2N
* supply rails (added; not part of the CI2N netlist)
Vsup_VDD VDD 0 {VDD}
.op
.end
