* CI2N circuit from experiments/04-hybrid-no-overlay/results/claude-sonnet-5.5-hybrid-no-overlay/golden/120.json
* ckt_type: SISO-Amplifier
* generated by ci2n_to_spice.py
* ---- placeholder values: CI2N netlists carry topology only; edit as needed ----
.param VDD=1.8 VSS=0
.param Rval=10k Cval=1p Ival=10u Vval=0.9
.param Wn=1u Ln=180n Wp=2u Lp=180n Aol=1e5
.model NMOS_CI2N NMOS (level=1 VTO=0.45 KP=200u LAMBDA=0.05)
.model PMOS_CI2N PMOS (level=1 VTO=-0.45 KP=80u LAMBDA=0.05)
.model NPN_CI2N NPN (Is=1e-16 Bf=100 Vaf=50)
.model PNP_CI2N PNP (Is=1e-16 Bf=50 Vaf=50)
.model D_CI2N D (Is=1e-14)

.subckt SISO_AMP in out
E1 out 0 in 0 {Aol}
.ends SISO_AMP

X1 net2 Vo SISO_AMP
X2 net1 net2 SISO_AMP
X3 Vin net1 SISO_AMP
C1 Vo 0 {Cval}
C2 net2 0 {Cval}
C3 net1 0 {Cval}
C4 net1 Vo {Cval}
C5 net2 Vo {Cval}
R1 Vo 0 {Rval}
R2 net2 0 {Rval}
R3 net1 0 {Rval}
.op
.end
