* CI2N circuit from experiments/04-hybrid-no-overlay/results/claude-sonnet-5.5-hybrid-no-overlay/golden/091.json
* ckt_type: DIDO-Amplifier
* generated by ci2n_to_spice.py
* ---- placeholder values: CI2N netlists carry topology only; edit as needed ----
.param VDD=1.8 VSS=0
.param Rval=10k Cval=1p Ival=10u Vval=0.9
.param Wn=1u Ln=180n Wp=2u Lp=180n Aol=1e5
.model NMOS_CI2N NMOS (level=1 VTO=0.45 KP=200u LAMBDA=0.05)
.model PMOS_CI2N PMOS (level=1 VTO=-0.45 KP=80u LAMBDA=0.05)
.model NPN_CI2N NPN (Is=1e-16 Bf=100 Vaf=50)
.model PNP_CI2N PNP (Is=1e-16 Bf=50 Vaf=50)
.model D_CI2N D (Is=1e-14)

M1 OUTP VBB4 net33 net33 PMOS_CI2N L={Lp} W={Wp}
M2 net33 VB2 VDD VDD PMOS_CI2N L={Lp} W={Wp}
M3 net34 VB2 VDD VDD PMOS_CI2N L={Lp} W={Wp}
M4 OUTN VBB4 net34 net34 PMOS_CI2N L={Lp} W={Wp}
M5 net31 Vi2 net19 net19 PMOS_CI2N L={Lp} W={Wp}
M6 net30 Vi1 net19 net19 PMOS_CI2N L={Lp} W={Wp}
M7 net19 VB1 VDD VDD PMOS_CI2N L={Lp} W={Wp}
M8 net31 Vcmc 0 0 NMOS_CI2N L={Ln} W={Wn}
M9 net30 Vcmc 0 0 NMOS_CI2N L={Ln} W={Wn}
M10 OUTN VBB3 net30 net30 NMOS_CI2N L={Ln} W={Wn}
M11 OUTP VBB3 net31 net31 NMOS_CI2N L={Ln} W={Wn}
* supply rails (added; not part of the CI2N netlist)
Vsup_VDD VDD 0 {VDD}
.op
.end
