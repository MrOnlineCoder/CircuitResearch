* CI2N circuit from experiments/04-hybrid-no-overlay/results/claude-sonnet-5.5-hybrid-no-overlay/golden/103.json
* ckt_type: DISO-Amplifier
* generated by ci2n_to_spice.py
* renamed nets: Vin- -> Vin_n, Vin+ -> Vin_p
* ---- placeholder values: CI2N netlists carry topology only; edit as needed ----
.param VDD=1.8 VSS=0
.param Rval=10k Cval=1p Ival=10u Vval=0.9
.param Wn=1u Ln=180n Wp=2u Lp=180n Aol=1e5
.model NMOS_CI2N NMOS (level=1 VTO=0.45 KP=200u LAMBDA=0.05)
.model PMOS_CI2N PMOS (level=1 VTO=-0.45 KP=80u LAMBDA=0.05)
.model NPN_CI2N NPN (Is=1e-16 Bf=100 Vaf=50)
.model PNP_CI2N PNP (Is=1e-16 Bf=50 Vaf=50)
.model D_CI2N D (Is=1e-14)

M1 VOUT VB6 net12 net12 PMOS_CI2N L={Lp} W={Wp}
M2 net11 VB6 net1 net1 PMOS_CI2N L={Lp} W={Wp}
M3 net12 net11 VDD VDD PMOS_CI2N L={Lp} W={Wp}
M4 net1 net11 VDD VDD PMOS_CI2N L={Lp} W={Wp}
M5 net6 Vin_n net2 net2 PMOS_CI2N L={Lp} W={Wp}
M6 net5 Vin_n net2 net2 PMOS_CI2N L={Lp} W={Wp}
M7 net4 Vin_p net2 net2 PMOS_CI2N L={Lp} W={Wp}
M8 net3 Vin_p net2 net2 PMOS_CI2N L={Lp} W={Wp}
M9 net2 VB1 net1 net1 PMOS_CI2N L={Lp} W={Wp}
M10 net14 VB4 net6 net6 NMOS_CI2N L={Ln} W={Wn}
M11 net13 VB4 net4 net4 NMOS_CI2N L={Ln} W={Wn}
M12 VOUT VB5 net14 net14 NMOS_CI2N L={Ln} W={Wn}
M13 net11 VB5 net13 net13 NMOS_CI2N L={Ln} W={Wn}
M14 net6 net3 0 0 NMOS_CI2N L={Ln} W={Wn}
M15 net10 net3 0 0 NMOS_CI2N L={Ln} W={Wn}
M16 net9 VB3 0 0 NMOS_CI2N L={Ln} W={Wn}
M17 net7 VB3 0 0 NMOS_CI2N L={Ln} W={Wn}
M18 net8 net5 0 0 NMOS_CI2N L={Ln} W={Wn}
M19 net4 net5 0 0 NMOS_CI2N L={Ln} W={Wn}
M20 net5 VB2 net7 net7 NMOS_CI2N L={Ln} W={Wn}
M21 net3 VB2 net10 net10 NMOS_CI2N L={Ln} W={Wn}
M22 net3 VB2 net9 net9 NMOS_CI2N L={Ln} W={Wn}
M23 net5 VB2 net8 net8 NMOS_CI2N L={Ln} W={Wn}
* supply rails (added; not part of the CI2N netlist)
Vsup_VDD VDD 0 {VDD}
.op
.end
