* CI2N circuit from experiments/04-hybrid-no-overlay/results/claude-sonnet-5.5-hybrid-no-overlay/golden/123.json
* ckt_type: Comparator
* generated by ci2n_to_spice.py
* renamed nets: FCLK$2 -> FCLK_2, FCLK$4 -> FCLK_4, FCLK$3 -> FCLK_3, FCLK$1 -> FCLK_1
* ---- placeholder values: CI2N netlists carry topology only; edit as needed ----
.param VDD=1.8 VSS=0
.param Rval=10k Cval=1p Ival=10u Vval=0.9
.param Wn=1u Ln=180n Wp=2u Lp=180n Aol=1e5
.model NMOS_CI2N NMOS (level=1 VTO=0.45 KP=200u LAMBDA=0.05)
.model PMOS_CI2N PMOS (level=1 VTO=-0.45 KP=80u LAMBDA=0.05)
.model NPN_CI2N NPN (Is=1e-16 Bf=100 Vaf=50)
.model PNP_CI2N PNP (Is=1e-16 Bf=50 Vaf=50)
.model D_CI2N D (Is=1e-14)

M1 net3 FCLK_2 net2 net2 PMOS_CI2N L={Lp} W={Wp}
M2 net2 net1 COMP COMP PMOS_CI2N L={Lp} W={Wp}
M3 net2 FCLK_4 VDD VDD PMOS_CI2N L={Lp} W={Wp}
M4 COMP net1 VDD VDD PMOS_CI2N L={Lp} W={Wp}
M5 COMP FCLK_4 VDD VDD PMOS_CI2N L={Lp} W={Wp}
M6 net1 COMP VDD VDD PMOS_CI2N L={Lp} W={Wp}
M7 net1 FCLK_3 VDD VDD PMOS_CI2N L={Lp} W={Wp}
M8 net4 FCLK_1 0 0 NMOS_CI2N L={Ln} W={Wn}
M9 net3 VREG net4 net4 NMOS_CI2N L={Ln} W={Wn}
M10 net2 VREF net4 net4 NMOS_CI2N L={Ln} W={Wn}
M11 net1 COMP net3 net3 NMOS_CI2N L={Ln} W={Wn}
M12 VDD FCLK_3 net3 net3 NMOS_CI2N L={Ln} W={Wn}
* supply rails (added; not part of the CI2N netlist)
Vsup_VDD VDD 0 {VDD}
.op
.end
