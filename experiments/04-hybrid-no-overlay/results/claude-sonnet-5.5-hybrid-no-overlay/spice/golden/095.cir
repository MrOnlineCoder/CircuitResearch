* CI2N circuit from experiments/04-hybrid-no-overlay/results/claude-sonnet-5.5-hybrid-no-overlay/golden/095.json
* ckt_type: DISO-Amplifier
* generated by ci2n_to_spice.py
* ---- placeholder values: CI2N netlists carry topology only; edit as needed ----
.param VDD=1.8 VSS=0
.param Rval=10k Cval=1p Ival=10u Vval=0.9
.param Wn=1u Ln=180n Wp=2u Lp=180n Aol=1e5
.model NMOS_CI2N NMOS (level=1 VTO=0.45 KP=200u LAMBDA=0.05)
.model PMOS_CI2N PMOS (level=1 VTO=-0.45 KP=80u LAMBDA=0.05)
.model NPN_CI2N NPN (Is=1e-16 Bf=100 Vaf=50)
.model PNP_CI2N PNP (Is=1e-16 Bf=50 Vaf=50)
.model D_CI2N D (Is=1e-14)

M1 OUT net14 VSS VSS NMOS_CI2N L={Ln} W={Wn}
M2 net1 net14 VSS VSS NMOS_CI2N L={Ln} W={Wn}
M3 net14 net14 VSS VSS NMOS_CI2N L={Ln} W={Wn}
M4 net22 vP net1 net1 NMOS_CI2N L={Ln} W={Wn}
M5 net17 vN net1 net1 NMOS_CI2N L={Ln} W={Wn}
M6 OUT net22 VDD VDD PMOS_CI2N L={Lp} W={Wp}
M7 net17 net17 VDD VDD PMOS_CI2N L={Lp} W={Wp}
M8 net22 net17 VDD VDD PMOS_CI2N L={Lp} W={Wp}
C1 OUT GND0 {Cval}
C2 net22 OUT {Cval}
C3 net17 VREF {Cval}
I1 VDD net14 {Ival}
* supply rails (added; not part of the CI2N netlist)
Vsup_VSS VSS 0 {VSS}
Vsup_VDD VDD 0 {VDD}
.op
.end
